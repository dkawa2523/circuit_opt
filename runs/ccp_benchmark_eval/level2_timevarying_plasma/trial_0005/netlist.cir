* Auto-generated simulation netlist for case: ccp_gec_level2_timevarying_plasma
.param C1=1.6963850574e-10
.param C2=1.37192623661e-10
.param Ch=5.03094004795e-12
.param L1=3.92769904866e-08
.param Lh=2.53823157014e-08
.param Vsrc_amp=544.789794892
.param Vsrc_dc=2.54525892036

* Sources
Vsrc src 0 SIN(2.54525892036 544.789794892 13560000 0 0 0)

* Circuit
C1 src 0 {C1}
L1 src electrode {L1}
C2 electrode 0 {C2}
Lh electrode harmonic_mid {Lh}
Ch harmonic_mid 0 {Ch}

* Optional load
* load model: plasma_table_rlcq
.subckt load_model p n
Rbulk p nb R = 'pwl(time, 0, 27.8335904937, 2e-10, 27.7371208077, 4e-10, 27.6403114571, 6e-10, 27.5432558023, 8e-10, 27.446043766, 1e-09, 27.3487618117, 1.2e-09, 27.2514929326, 1.4e-09, 27.1543166502, 1.6e-09, 27.0573090219, 1.8e-09, 26.9605426567, 2e-09, 26.8640867386, 2.2e-09, 26.7680070573, 2.4e-09, 26.6723660444, 2.6e-09, 26.577222816, 2.8e-09, 26.4826332203, 3e-09, 26.388649889, 3.2e-09, 26.2953222937, 3.4e-09, 26.2026968053, 3.6e-09, 26.1108167558, 3.8e-09, 26.0197225039, 4e-09, 25.9294515016, 4.2e-09, 25.8400383633, 4.4e-09, 25.7515149354, 4.6e-09, 25.6639103681, 4.8e-09, 25.5772511868, 5e-09, 25.4915613644, 5.2e-09, 25.4068623943, 5.4e-09, 25.3231733623, 5.6e-09, 25.2405110189, 5.8e-09, 25.1588898513, 6e-09, 25.0783221544, 6.2e-09, 24.9988181012, 6.4e-09, 24.9203858126, 6.6e-09, 24.8430314255, 6.8e-09, 24.7667591607, 7e-09, 24.6915713894, 7.2e-09, 24.6174686982, 7.4e-09, 24.544449953, 7.6e-09, 24.4725123621, 7.8e-09, 24.4016515373, 8e-09, 24.3318615543, 8.2e-09, 24.2631350117, 8.4e-09, 24.1954630882, 8.6e-09, 24.1288355995, 8.8e-09, 24.063241053, 9e-09, 23.9986667022, 9.2e-09, 23.9350985993, 9.4e-09, 23.8725216467, 9.6e-09, 23.8109196482, 9.8e-09, 23.7502753579, 1e-08, 23.6905705298, 1.02e-08, 23.6317859648, 1.04e-08, 23.573901558, 1.06e-08, 23.5168963451, 1.08e-08, 23.4607485475, 1.1e-08, 23.4054356172, 1.12e-08, 23.3509342815, 1.14e-08, 23.2972205861, 1.16e-08, 23.2442699387, 1.18e-08, 23.1920571518, 1.2e-08, 23.1405564853, 1.22e-08, 23.0897416886, 1.24e-08, 23.0395860424, 1.26e-08, 22.990062401, 1.28e-08, 22.9411432334, 1.3e-08, 22.8928006651, 1.32e-08, 22.8450065198, 1.34e-08, 22.7977323605, 1.36e-08, 22.7509495309, 1.38e-08, 22.7046291975, 1.4e-08, 22.6587423905, 1.42e-08, 22.6132600459, 1.44e-08, 22.5681530471, 1.46e-08, 22.5233922665, 1.48e-08, 22.4789486078, 1.5e-08, 22.4347930477, 1.52e-08, 22.3908966782, 1.54e-08, 22.3472307486, 1.56e-08, 22.3037667079, 1.58e-08, 22.2604762468, 1.6e-08, 22.2173313401, 1.62e-08, 22.1743042889, 1.64e-08, 22.1313677624, 1.66e-08, 22.0884948401, 1.68e-08, 22.0456590536, 1.7e-08, 22.0028344278, 1.72e-08, 21.9599955223, 1.74e-08, 21.9171174723, 1.76e-08, 21.8741760285, 1.78e-08, 21.8311475975, 1.8e-08, 21.7880092805, 1.82e-08, 21.7447389122, 1.84e-08, 21.7013150982, 1.86e-08, 21.6577172521, 1.88e-08, 21.6139256315, 1.9e-08, 21.5699213725, 1.92e-08, 21.5256865239, 1.94e-08, 21.4812040794, 1.96e-08, 21.4364580091, 1.98e-08, 21.3914332888, 2e-08, 21.3461159288, 2.02e-08, 21.3004930006, 2.04e-08, 21.2545526615, 2.06e-08, 21.2082841785, 2.08e-08, 21.1616779493, 2.1e-08, 21.114725522, 2.12e-08, 21.0674196132, 2.14e-08, 21.0197541229, 2.16e-08, 20.9717241483, 2.18e-08, 20.9233259953, 2.2e-08, 20.8745571877, 2.22e-08, 20.825416474, 2.24e-08, 20.7759038321, 2.26e-08, 20.7260204721, 2.28e-08, 20.6757688362, 2.3e-08, 20.6251525966, 2.32e-08, 20.5741766513, 2.34e-08, 20.5228471174, 2.36e-08, 20.471171322, 2.38e-08, 20.4191577915, 2.4e-08, 20.3668162376, 2.42e-08, 20.3141575426, 2.44e-08, 20.2611937412, 2.46e-08, 20.2079380015, 2.48e-08, 20.1544046027, 2.5e-08, 20.1006089125, 2.52e-08, 20.0465673614, 2.54e-08, 19.9922974155, 2.56e-08, 19.9378175484, 2.58e-08, 19.8831472111, 2.6e-08, 19.8283068, 2.62e-08, 19.7733176244, 2.64e-08, 19.7182018725, 2.66e-08, 19.662982576, 2.68e-08, 19.6076835745, 2.7e-08, 19.5523294782, 2.72e-08, 19.4969456304, 2.74e-08, 19.4415580692, 2.76e-08, 19.3861934891, 2.78e-08, 19.3308792016, 2.8e-08, 19.275643096, 2.82e-08, 19.2205136003, 2.84e-08, 19.1655196417, 2.86e-08, 19.1106906071, 2.88e-08, 19.0560563045, 2.9e-08, 19.0016469243, 2.92e-08, 18.9474930007, 2.94e-08, 18.8936253748, 2.96e-08, 18.8400751568, 2.98e-08, 18.7868736903, 3e-08, 18.7340525168, 3.02e-08, 18.6816433411, 3.04e-08, 18.6296779977, 3.06e-08, 18.5781884182, 3.08e-08, 18.5272066004, 3.1e-08, 18.4767645775, 3.12e-08, 18.4268943895, 3.14e-08, 18.3776280549, 3.16e-08, 18.3289975449, 3.18e-08, 18.2810347577, 3.2e-08, 18.2337714951, 3.22e-08, 18.1872394395, 3.24e-08, 18.1414701335, 3.26e-08, 18.0964949594, 3.28e-08, 18.0523451218, 3.3e-08, 18.00905163, 3.32e-08, 17.9666452824, 3.34e-08, 17.9251566529, 3.36e-08, 17.8846160773, 3.38e-08, 17.8450536425, 3.4e-08, 17.8064991754, 3.42e-08, 17.7689822346, 3.44e-08, 17.7325321023, 3.46e-08, 17.6971777776, 3.48e-08, 17.6629479714, 3.5e-08, 17.6298711015, 3.52e-08, 17.5979752901, 3.54e-08, 17.5672883606, 3.56e-08, 17.537837837, 3.58e-08, 17.5096509431, 3.6e-08, 17.4827546028, 3.62e-08, 17.4571754417, 3.64e-08, 17.4329397887, 3.66e-08, 17.4100736787, 3.68e-08, 17.388602856, 3.7e-08, 17.3685527777, 3.72e-08, 17.3499486182, 3.74e-08, 17.3328152741, 3.76e-08, 17.3171773686, 3.78e-08, 17.3030592577, 3.8e-08, 17.2904850351, 3.82e-08, 17.2794785384, 3.84e-08, 17.2700633547, 3.86e-08, 17.2622628267, 3.88e-08, 17.2561000585, 3.9e-08, 17.2515979217, 3.92e-08, 17.2487790604, 3.94e-08, 17.2476658974, 3.96e-08, 17.2482806391, 3.98e-08, 17.25064528, 4e-08, 17.2547816075, 4.02e-08, 17.2607112056, 4.04e-08, 17.2684554587, 4.06e-08, 17.2780355534, 4.08e-08, 17.2894724818, 4.1e-08, 17.3027870417, 4.12e-08, 17.317999838, 4.14e-08, 17.3351312817, 4.16e-08, 17.3542015888, 4.18e-08, 17.3752307777, 4.2e-08, 17.3982386663, 4.22e-08, 17.4232448665, 4.24e-08, 17.450268779, 4.26e-08, 17.4793295858, 4.28e-08, 17.5104462414, 4.3e-08, 17.5436374629, 4.32e-08, 17.5789217186, 4.34e-08, 17.6163172143, 4.36e-08, 17.6558418784, 4.38e-08, 17.6975133455, 4.4e-08, 17.7413489375, 4.42e-08, 17.7873656431, 4.44e-08, 17.8355800952, 4.46e-08, 17.8860085465, 4.48e-08, 17.9386668422, 4.5e-08, 17.9935703913, 4.52e-08, 18.0507341351, 4.54e-08, 18.1101725131, 4.56e-08, 18.1718994271, 4.58e-08, 18.2359282015, 4.6e-08, 18.3022715428, 4.62e-08, 18.3709414943, 4.64e-08, 18.4419493896, 4.66e-08, 18.5153058026, 4.68e-08, 18.5910204945, 4.7e-08, 18.6691023579, 4.72e-08, 18.7495593584, 4.74e-08, 18.8323984722, 4.76e-08, 18.9176256213, 4.78e-08, 19.0052456053, 4.8e-08, 19.0952620302, 4.82e-08, 19.1876772337, 4.84e-08, 19.2824922076, 4.86e-08, 19.3797065174, 4.88e-08, 19.4793182177, 4.9e-08, 19.5813237658, 4.92e-08, 19.6857179313, 4.94e-08, 19.7924937036, 4.96e-08, 19.9016421957, 4.98e-08, 20.0131525458, 5e-08, 20.1270118166, 5.02e-08, 20.2432048915, 5.04e-08, 20.3617143691, 5.06e-08, 20.4825204556, 5.08e-08, 20.6056008555, 5.1e-08, 20.7309306609, 5.12e-08, 20.8584822397, 5.14e-08, 20.988225123, 5.16e-08, 21.1201258919, 5.18e-08, 21.2541480654, 5.2e-08, 21.3902519874, 5.22e-08, 21.5283947157, 5.24e-08, 21.6685299127, 5.26e-08, 21.8106077379, 5.28e-08, 21.954574743, 5.3e-08, 22.1003737714, 5.32e-08, 22.2479438614, 5.34e-08, 22.397220154, 5.36e-08, 22.5481338074, 5.38e-08, 22.7006119174, 5.4e-08, 22.8545774456, 5.42e-08, 23.0099491557, 5.44e-08, 23.1666415596, 5.46e-08, 23.3245648731, 5.48e-08, 23.4836249833, 5.5e-08, 23.6437234278, 5.52e-08, 23.804757387, 5.54e-08, 23.9666196912, 5.56e-08, 24.1291988414, 5.58e-08, 24.2923790477, 5.6e-08, 24.4560402831, 5.62e-08, 24.6200583559, 5.64e-08, 24.7843050007, 5.66e-08, 24.9486479882, 5.68e-08, 25.1129512554, 5.7e-08, 25.2770750565, 5.72e-08, 25.4408761341, 5.74e-08, 25.6042079131, 5.76e-08, 25.7669207153, 5.78e-08, 25.9288619964, 5.8e-08, 26.089876605, 5.82e-08, 26.2498070627, 5.84e-08, 26.4084938661, 5.86e-08, 26.56577581, 5.88e-08, 26.7214903296, 5.9e-08, 26.8754738639, 5.92e-08, 27.0275622355, 5.94e-08, 27.177591049, 5.96e-08, 27.3253961044, 5.98e-08, 27.4708138245, 6e-08, 27.613681695, 6.02e-08, 27.7538387147, 6.04e-08, 27.891125854, 6.06e-08, 28.0253865189, 6.08e-08, 28.1564670196, 6.1e-08, 28.2842170391, 6.12e-08, 28.4084901005, 6.14e-08, 28.52914403, 6.16e-08, 28.6460414135, 6.18e-08, 28.7590500418, 6.2e-08, 28.8680433451, 6.22e-08, 28.9729008103, 6.24e-08, 29.0735083816, 6.26e-08, 29.1697588397, 6.28e-08, 29.2615521577, 6.3e-08, 29.3487958318, 6.32e-08, 29.4314051836, 6.34e-08, 29.5093036331, 6.36e-08, 29.5824229398, 6.38e-08, 29.6507034101, 6.4e-08, 29.7140940705, 6.42e-08, 29.7725528051, 6.44e-08, 29.8260464562, 6.46e-08, 29.8745508878, 6.48e-08, 29.9180510125, 6.5e-08, 29.9565407798, 6.52e-08, 29.9900231287, 6.54e-08, 30.0185099032, 6.56e-08, 30.0420217321, 6.58e-08, 30.0605878755, 6.6e-08, 30.0742460367, 6.62e-08, 30.083042144, 6.64e-08, 30.0870301026, 6.66e-08, 30.0862715178, 6.68e-08, 30.0808353947, 6.7e-08, 30.0707978125, 6.72e-08, 30.0562415795, 6.74e-08, 30.0372558689, 6.76e-08, 30.0139358393, 6.78e-08, 29.986382241, 6.8e-08, 29.9547010125, 6.82e-08, 29.9190028683, 6.84e-08, 29.8794028805, 6.86e-08, 29.8360200578, 6.88e-08, 29.7889769234, 6.9e-08, 29.7383990933, 6.92e-08, 29.6844148593, 6.94e-08, 29.6271547765, 6.96e-08, 29.5667512581, 6.98e-08, 29.5033381797, 7e-08, 29.4370504936, 7.02e-08, 29.3680238555, 7.04e-08, 29.2963942641, 7.06e-08, 29.2222977151, 7.08e-08, 29.1458698709, 7.1e-08, 29.0672457452, 7.12e-08, 28.9865594057, 7.14e-08, 28.9039436928, 7.16e-08, 28.8195299562, 7.18e-08, 28.7334478093, 7.2e-08, 28.6458249011, 7.22e-08, 28.5567867062, 7.24e-08, 28.4664563316, 7.26e-08, 28.3749543419, 7.28e-08, 28.2823986008, 7.3e-08, 28.1889041294, 7.32e-08, 28.0945829807, 7.34e-08, 27.9995441296, 7.36e-08, 27.9038933784, 7.38e-08, 27.8077332759, 7.4e-08, 27.7111630509, 7.42e-08, 27.6142785585, 7.44e-08, 27.517172239, 7.46e-08, 27.4199330883, 7.48e-08, 27.322646639, 7.5e-08, 27.2253949522, 7.52e-08, 27.1282566182, 7.54e-08, 27.031306767, 7.56e-08, 26.9346170855, 7.58e-08, 26.8382558434, 7.6e-08, 26.7422879251, 7.62e-08, 26.6467748678, 7.64e-08, 26.5517749055, 7.66e-08, 26.4573430176, 7.68e-08, 26.3635309821, 7.7e-08, 26.2703874322, 7.72e-08, 26.1779579167, 7.74e-08, 26.0862849632, 7.76e-08, 25.9954081432, 7.78e-08, 25.9053641405, 7.8e-08, 25.8161868192, 7.82e-08, 25.7279072952, 7.84e-08, 25.6405540068, 7.86e-08, 25.5541527872, 7.88e-08, 25.4687269367, 7.9e-08, 25.3842972951, 7.92e-08, 25.3008823144, 7.94e-08, 25.2184981305, 7.96e-08, 25.1371586351, 7.98e-08, 25.0568755466, 8e-08, 24.9776584805, 8.02e-08, 24.8995150182, 8.04e-08, 24.8224507758, 8.06e-08, 24.7464694712, 8.08e-08, 24.6715729901, 8.1e-08, 24.5977614509, 8.12e-08, 24.5250332686, 8.14e-08, 24.4533852168, 8.16e-08, 24.3828124892, 8.18e-08, 24.3133087592, 8.2e-08, 24.2448662387, 8.22e-08, 24.177475735, 8.24e-08, 24.1111267072, 8.26e-08, 24.0458073209, 8.28e-08, 23.9815045021, 8.3e-08, 23.9182039891, 8.32e-08, 23.8558903846, 8.34e-08, 23.7945472057, 8.36e-08, 23.7341569335, 8.38e-08, 23.6747010612, 8.4e-08, 23.6161601422, 8.42e-08, 23.5585138363, 8.44e-08, 23.5017409562, 8.46e-08, 23.4458195123, 8.48e-08, 23.390726758, 8.5e-08, 23.336439233, 8.52e-08, 23.2829328078, 8.54e-08, 23.230182726, 8.56e-08, 23.1781636476, 8.58e-08, 23.1268496914, 8.6e-08, 23.0762144767, 8.62e-08, 23.0262311659, 8.64e-08, 22.9768725056, 8.66e-08, 22.9281108686, 8.68e-08, 22.8799182954, 8.7e-08, 22.8322665353, 8.72e-08, 22.7851270887, 8.74e-08, 22.7384712476, 8.76e-08, 22.6922701377, 8.78e-08, 22.6464947599, 8.8e-08, 22.601116032, 8.82e-08, 22.5561048303, 8.84e-08, 22.5114320315, 8.86e-08, 22.4670685547, 8.88e-08, 22.4229854036, 8.9e-08, 22.379153708, 8.92e-08, 22.3355447669, 8.94e-08, 22.29213009, 8.96e-08, 22.24888144, 8.98e-08, 22.2057708752, 9e-08, 22.1627707914, 9.02e-08, 22.1198539639, 9.04e-08, 22.0769935894, 9.06e-08, 22.0341633278, 9.08e-08, 21.9913373437, 9.1e-08, 21.948490347, 9.12e-08, 21.9055976343, 9.14e-08, 21.8626351284, 9.16e-08, 21.8195794186, 9.18e-08, 21.7764077993, 9.2e-08, 21.7330983083, 9.22e-08, 21.6896297647, 9.24e-08, 21.6459818051, 9.26e-08, 21.6021349195, 9.28e-08, 21.5580704858, 9.3e-08, 21.5137708032, 9.32e-08, 21.4692191247, 9.34e-08, 21.4243996872, 9.36e-08, 21.3792977418, 9.38e-08, 21.3338995809, 9.4e-08, 21.2881925652, 9.42e-08, 21.2421651476, 9.44e-08, 21.1958068965, 9.46e-08, 21.1491085168, 9.48e-08, 21.1020618685, 9.5e-08, 21.0546599843, 9.52e-08, 21.0068970844, 9.54e-08, 20.9587685896, 9.56e-08, 20.9102711318, 9.58e-08, 20.8614025629, 9.6e-08, 20.8121619611, 9.62e-08, 20.7625496349, 9.64e-08, 20.7125671253, 9.66e-08, 20.6622172048, 9.68e-08, 20.6115038753, 9.7e-08, 20.5604323629, 9.72e-08, 20.5090091103, 9.74e-08, 20.4572417678, 9.76e-08, 20.4051391813, 9.78e-08, 20.3527113785, 9.8e-08, 20.2999695527, 9.82e-08, 20.2469260449, 9.84e-08, 20.1935943236, 9.86e-08, 20.1399889627, 9.88e-08, 20.0861256176, 9.9e-08, 20.0320209996, 9.92e-08, 19.9776928482, 9.94e-08, 19.9231599023, 9.96e-08, 19.8684418697, 9.98e-08, 19.8135593953, 1e-07, 19.7585340277, 1.002e-07, 19.7033881849, 1.004e-07, 19.6481451193, 1.006e-07, 19.5928288808, 1.008e-07, 19.5374642801, 1.01e-07, 19.4820768509, 1.012e-07, 19.4266928112, 1.014e-07, 19.3713390251, 1.016e-07, 19.3160429629, 1.018e-07, 19.2608326626, 1.02e-07, 19.2057366899, 1.022e-07, 19.1507840993, 1.024e-07, 19.0960043945, 1.026e-07, 19.04142749, 1.028e-07, 18.9870836721, 1.03e-07, 18.9330035612, 1.032e-07, 18.8792180741, 1.034e-07, 18.8257583873, 1.036e-07, 18.772655901, 1.038e-07, 18.7199422037, 1.04e-07, 18.6676490384, 1.042e-07, 18.6158082688, 1.044e-07, 18.5644518473, 1.046e-07, 18.5136117841, 1.048e-07, 18.463320117, 1.05e-07, 18.4136088829, 1.052e-07, 18.3645100903, 1.054e-07, 18.3160556931, 1.056e-07, 18.2682775659, 1.058e-07, 18.2212074805, 1.06e-07, 18.174877084, 1.062e-07, 18.1293178777, 1.064e-07, 18.084561198, 1.066e-07, 18.0406381986, 1.068e-07, 17.9975798337, 1.07e-07, 17.9554168429, 1.072e-07, 17.9141797372, 1.074e-07, 17.8738987868, 1.076e-07, 17.8346040097, 1.078e-07, 17.7963251617, 1.08e-07, 17.7590917277, 1.082e-07, 17.7229329147, 1.084e-07, 17.6878776449, 1.086e-07, 17.6539545509, 1.088e-07, 17.6211919714, 1.09e-07, 17.5896179485, 1.092e-07, 17.5592602255, 1.094e-07, 17.5301462457, 1.096e-07, 17.5023031524, 1.098e-07, 17.4757577892, 1.1e-07, 17.4505367018, 1.102e-07, 17.42666614, 1.104e-07, 17.4041720604, 1.106e-07, 17.3830801296, 1.108e-07, 17.3634157286, 1.11e-07, 17.3452039567, 1.112e-07, 17.3284696364, 1.114e-07, 17.3132373189, 1.116e-07, 17.2995312891, 1.118e-07, 17.2873755714, 1.12e-07, 17.2767939355, 1.122e-07, 17.2678099025, 1.124e-07, 17.2604467503, 1.126e-07, 17.2547275202, 1.128e-07, 17.2506750219, 1.13e-07, 17.2483118398, 1.132e-07, 17.2476603381, 1.134e-07, 17.2487426658, 1.136e-07, 17.2515807614, 1.138e-07, 17.2561963574, 1.14e-07, 17.2626109838, 1.142e-07, 17.2708459717, 1.144e-07, 17.2809224554, 1.146e-07, 17.2928613747, 1.148e-07, 17.3066834756, 1.15e-07, 17.3224093109, 1.152e-07, 17.3400592396, 1.154e-07, 17.3596534249, 1.156e-07, 17.3812118317, 1.158e-07, 17.4047542232, 1.16e-07, 17.4303001552, 1.162e-07, 17.4578689705, 1.164e-07, 17.4874797908, 1.166e-07, 17.519151508, 1.168e-07, 17.5529027738, 1.17e-07, 17.5887519872, 1.172e-07, 17.626717281, 1.174e-07, 17.6668165067, 1.176e-07, 17.7090672167, 1.178e-07, 17.7534866456, 1.18e-07, 17.8000916889, 1.182e-07, 17.84889888, 1.184e-07, 17.8999243648, 1.186e-07, 17.9531838744, 1.188e-07, 18.0086926956, 1.19e-07, 18.0664656383, 1.192e-07, 18.1265170013, 1.194e-07, 18.1888605354, 1.196e-07, 18.2535094033, 1.198e-07, 18.320476138, 1.2e-07, 18.3897725969, 1.202e-07, 18.4614099148, 1.204e-07, 18.5353984527, 1.206e-07, 18.6117477442, 1.208e-07, 18.6904664391, 1.21e-07, 18.7715622435, 1.212e-07, 18.8550418572, 1.214e-07, 18.9409109077, 1.216e-07, 19.0291738814, 1.218e-07, 19.1198340511, 1.22e-07, 19.2128934011, 1.222e-07, 19.3083525484, 1.224e-07, 19.4062106612, 1.226e-07, 19.5064653741, 1.228e-07, 19.6091127002, 1.23e-07, 19.7141469407, 1.232e-07, 19.8215605905, 1.234e-07, 19.9313442425, 1.236e-07, 20.0434864878, 1.238e-07, 20.1579738142, 1.24e-07, 20.2747905023, 1.242e-07, 20.3939185192, 1.244e-07, 20.5153374102, 1.246e-07, 20.6390241896, 1.248e-07, 20.7649532292, 1.25e-07, 20.8930961464, 1.252e-07, 21.0234216916, 1.254e-07, 21.155895635, 1.256e-07, 21.2904806541, 1.258e-07, 21.4271362217, 1.26e-07, 21.5658184949, 1.262e-07, 21.7064802061, 1.264e-07, 21.8490705565, 1.266e-07, 21.9935351121, 1.268e-07, 22.1398157042, 1.27e-07, 22.2878503337, 1.272e-07, 22.4375730806, 1.274e-07, 22.5889140202, 1.276e-07, 22.7417991452, 1.278e-07, 22.8961502962, 1.28e-07, 23.0518851005, 1.282e-07, 23.2089169206, 1.284e-07, 23.3671548131, 1.286e-07, 23.526503499, 1.288e-07, 23.6868633465, 1.29e-07, 23.848130367, 1.292e-07, 24.0101962258, 1.294e-07, 24.1729482678, 1.296e-07, 24.3362695596, 1.298e-07, 24.5000389483, 1.3e-07, 24.6641311392, 1.302e-07, 24.828416791, 1.304e-07, 24.9927626319, 1.306e-07, 25.1570315944, 1.308e-07, 25.3210829724, 1.31e-07, 25.4847725981, 1.312e-07, 25.6479530412, 1.314e-07, 25.8104738302, 1.316e-07, 25.9721816946, 1.318e-07, 26.1329208298, 1.32e-07, 26.2925331833, 1.322e-07, 26.4508587624, 1.324e-07, 26.6077359624, 1.326e-07, 26.7630019147, 1.328e-07, 26.9164928548, 1.33e-07, 27.068044507, 1.332e-07, 27.2174924871, 1.334e-07, 27.3646727197, 1.336e-07, 27.5094218694, 1.338e-07, 27.6515777834, 1.34e-07, 27.7909799445, 1.342e-07, 27.927469931, 1.344e-07, 28.0608918827, 1.346e-07, 28.1910929689, 1.348e-07, 28.3179238577, 1.35e-07, 28.4412391821, 1.352e-07, 28.5608980017, 1.354e-07, 28.6767642561, 1.356e-07, 28.7887072081, 1.358e-07, 28.8966018731, 1.36e-07, 29.0003294332, 1.362e-07, 29.0997776314, 1.364e-07, 29.194841145, 1.366e-07, 29.2854219354, 1.368e-07, 29.3714295708, 1.37e-07, 29.4527815213, 1.372e-07, 29.5294034232, 1.374e-07, 29.6012293112, 1.376e-07, 29.6682018172, 1.378e-07, 29.7302723332, 1.38e-07, 29.7874011398, 1.382e-07, 29.8395574963, 1.384e-07, 29.8867196946, 1.386e-07, 29.9288750758, 1.388e-07, 29.9660200088, 1.39e-07, 29.9981598327, 1.392e-07, 30.0253087629, 1.394e-07, 30.0474897618, 1.396e-07, 30.0647343755, 1.398e-07, 30.0770825381, 1.4e-07, 30.0845823447, 1.402e-07, 30.0872897955, 1.404e-07, 30.0852685132, 1.406e-07, 30.0785894342, 1.408e-07, 30.0673304791, 1.41e-07, 30.051576201, 1.412e-07, 30.0314174178, 1.414e-07, 30.0069508281, 1.416e-07, 29.9782786152, 1.418e-07, 29.9455080402, 1.42e-07, 29.9087510285, 1.422e-07, 29.8681237506, 1.424e-07, 29.8237462, 1.426e-07, 29.7757417712, 1.428e-07, 29.7242368396, 1.43e-07, 29.6693603445, 1.432e-07, 29.6112433793, 1.434e-07, 29.5500187882, 1.436e-07, 29.4858207733, 1.438e-07, 29.4187845118, 1.44e-07, 29.3490457862, 1.442e-07, 29.2767406279, 1.444e-07, 29.2020049748, 1.446e-07, 29.1249743455, 1.448e-07, 29.0457835282, 1.45e-07, 28.9645662881, 1.452e-07, 28.8814550906, 1.454e-07, 28.7965808426, 1.456e-07, 28.7100726519, 1.458e-07, 28.6220576037, 1.46e-07, 28.5326605552, 1.462e-07, 28.4420039476, 1.464e-07, 28.3502076352, 1.466e-07, 28.2573887318, 1.468e-07, 28.1636614735, 1.47e-07, 28.0691370971, 1.472e-07, 27.9739237348, 1.474e-07, 27.8781263226, 1.476e-07, 27.7818465242, 1.478e-07, 27.6851826675, 1.48e-07, 27.5882296946, 1.482e-07, 27.4910791235, 1.484e-07, 27.3938190218, 1.486e-07, 27.2965339906, 1.488e-07, 27.199305159, 1.49e-07, 27.1022101871, 1.492e-07, 27.0053232785, 1.494e-07, 26.9087152, 1.496e-07, 26.8124533091, 1.498e-07, 26.7166015878, 1.5e-07, 26.621220682, 1.502e-07, 26.5263679472, 1.504e-07, 26.432097498, 1.506e-07, 26.3384602623, 1.508e-07, 26.2455040396, 1.51e-07, 26.1532735611, 1.512e-07, 26.0618105546, 1.514e-07, 25.9711538096, 1.516e-07, 25.8813392461, 1.518e-07, 25.7923999837, 1.52e-07, 25.7043664123, 1.522e-07, 25.6172662639, 1.524e-07, 25.5311246847, 1.526e-07, 25.4459643073, 1.528e-07, 25.3618053235, 1.53e-07, 25.2786655564, 1.532e-07, 25.1965605325, 1.534e-07, 25.1155035534, 1.536e-07, 25.0355057658, 1.538e-07, 24.9565762326, 1.54e-07, 24.878722001, 1.542e-07, 24.801948171, 1.544e-07, 24.726257962, 1.546e-07, 24.6516527792, 1.548e-07, 24.5781322775, 1.55e-07, 24.5056944252, 1.552e-07, 24.4343355659, 1.554e-07, 24.3640504793, 1.556e-07, 24.2948324408, 1.558e-07, 24.2266732796, 1.56e-07, 24.1595634358, 1.562e-07, 24.0934920159, 1.564e-07, 24.0284468475, 1.566e-07, 23.9644145326, 1.568e-07, 23.9013804998, 1.57e-07, 23.8393290553, 1.572e-07, 23.7782434335, 1.574e-07, 23.7181058454, 1.576e-07, 23.6588975275, 1.578e-07, 23.6005987885, 1.58e-07, 23.5431890565, 1.582e-07, 23.4866469244, 1.584e-07, 23.430950195, 1.586e-07, 23.3760759258, 1.588e-07, 23.3220004726, 1.59e-07, 23.2686995334, 1.592e-07, 23.216148191, 1.594e-07, 23.164320956, 1.596e-07, 23.1131918088, 1.598e-07, 23.0627342422, 1.6e-07, 23.0129213027, 1.602e-07, 22.9637256325, 1.604e-07, 22.9151195112, 1.606e-07, 22.867074897, 1.608e-07, 22.8195634684, 1.61e-07, 22.7725566656, 1.612e-07, 22.726025732, 1.614e-07, 22.6799417558, 1.616e-07, 22.6342757114, 1.618e-07, 22.5889985014, 1.62e-07, 22.5440809979, 1.622e-07, 22.4994940852, 1.624e-07, 22.4552087007, 1.626e-07, 22.4111958779, 1.628e-07, 22.3674267879, 1.63e-07, 22.3238727821, 1.632e-07, 22.280505434, 1.634e-07, 22.2372965814, 1.636e-07, 22.1942183692, 1.638e-07, 22.1512432909, 1.64e-07, 22.1083442307, 1.642e-07, 22.0654945058, 1.644e-07, 22.0226679073, 1.646e-07, 21.9798387421, 1.648e-07, 21.9369818739, 1.65e-07, 21.8940727633, 1.652e-07, 21.8510875083, 1.654e-07, 21.8080028834, 1.656e-07, 21.7647963789, 1.658e-07, 21.7214462389, 1.66e-07, 21.6779314981, 1.662e-07, 21.6342320189, 1.664e-07, 21.5903285262, 1.666e-07, 21.5462026421, 1.668e-07, 21.5018369187, 1.67e-07, 21.45721487, 1.672e-07, 21.4123210026, 1.674e-07, 21.3671408441, 1.676e-07, 21.3216609715, 1.678e-07, 21.275869036, 1.68e-07, 21.2297537881, 1.682e-07, 21.1833050991, 1.684e-07, 21.1365139821, 1.686e-07, 21.0893726106, 1.688e-07, 21.0418743345, 1.69e-07, 20.9940136951, 1.692e-07, 20.9457864373, 1.694e-07, 20.8971895198, 1.696e-07, 20.8482211232, 1.698e-07, 20.7988806555, 1.7e-07, 20.7491687561, 1.702e-07, 20.6990872966, 1.704e-07, 20.64863938, 1.706e-07, 20.5978293373, 1.708e-07, 20.546662722, 1.71e-07, 20.4951463021, 1.712e-07, 20.4432880499, 1.714e-07, 20.3910971302, 1.716e-07, 20.338583885, 1.718e-07, 20.2857598178, 1.72e-07, 20.2326375742, 1.722e-07, 20.1792309217, 1.724e-07, 20.1255547269, 1.726e-07, 20.0716249313, 1.728e-07, 20.0174585249, 1.73e-07, 19.9630735183, 1.732e-07, 19.9084889138, 1.734e-07, 19.8537246738, 1.736e-07, 19.7988016891, 1.738e-07, 19.7437417451, 1.74e-07, 19.6885674872, 1.742e-07, 19.6333023856, 1.744e-07, 19.5779706981, 1.746e-07, 19.5225974332, 1.748e-07, 19.467208312, 1.75e-07, 19.4118297298, 1.752e-07, 19.3564887174, 1.754e-07, 19.3012129012, 1.756e-07, 19.2460304647, 1.758e-07, 19.1909701088, 1.76e-07, 19.1360610124, 1.762e-07, 19.0813327932, 1.764e-07, 19.0268154693, 1.766e-07, 18.9725394205, 1.768e-07, 18.9185353503, 1.77e-07, 18.8648342488, 1.772e-07, 18.8114673561, 1.774e-07, 18.7584661263, 1.776e-07, 18.7058621928, 1.778e-07, 18.6536873341, 1.78e-07, 18.6019734409, 1.782e-07, 18.5507524841, 1.784e-07, 18.5000564842, 1.786e-07, 18.4499174816, 1.788e-07, 18.4003675081, 1.79e-07, 18.3514385601, 1.792e-07, 18.3031625726, 1.794e-07, 18.2555713949, 1.796e-07, 18.2086967674, 1.798e-07, 18.1625702999, 1.8e-07, 18.1172234515, 1.802e-07, 18.0726875111, 1.804e-07, 18.0289935806, 1.806e-07, 17.9861725578, 1.808e-07, 17.9442551223, 1.81e-07, 17.9032717218, 1.812e-07, 17.8632525596, 1.814e-07, 17.8242275844, 1.816e-07, 17.7862264801, 1.818e-07, 17.7492786577, 1.82e-07, 17.7134132481, 1.822e-07, 17.6786590964, 1.824e-07, 17.6450447566, 1.826e-07, 17.6125984882, 1.828e-07, 17.581348253, 1.83e-07, 17.551321714, 1.832e-07, 17.5225462339, 1.834e-07, 17.4950488754, 1.836e-07, 17.4688564021, 1.838e-07, 17.44399528, 1.84e-07, 17.4204916799, 1.842e-07, 17.39837148, 1.844e-07, 17.3776602701, 1.846e-07, 17.3583833549, 1.848e-07, 17.3405657591, 1.85e-07, 17.3242322318, 1.852e-07, 17.3094072522, 1.854e-07, 17.2961150346, 1.856e-07, 17.2843795345, 1.858e-07, 17.2742244544, 1.86e-07, 17.2656732494, 1.862e-07, 17.2587491333, 1.864e-07, 17.2534750847, 1.866e-07, 17.2498738524, 1.868e-07, 17.2479679611, 1.87e-07, 17.2477797166, 1.872e-07, 17.2493312111, 1.874e-07, 17.2526443274, 1.876e-07, 17.2577407433, 1.878e-07, 17.2646419351, 1.88e-07, 17.2733691807, 1.882e-07, 17.2839435623, 1.884e-07, 17.2963859673, 1.886e-07, 17.3107170902, 1.888e-07, 17.3269574316, 1.89e-07, 17.3451272982, 1.892e-07, 17.3652468004, 1.894e-07, 17.3873358493, 1.896e-07, 17.4114141528, 1.898e-07, 17.4375012105, 1.9e-07, 17.4656163064, 1.902e-07, 17.4957785016, 1.904e-07, 17.5280066247, 1.906e-07, 17.5623192605, 1.908e-07, 17.5987347382, 1.91e-07, 17.6372711167, 1.912e-07, 17.6779461688, 1.914e-07, 17.7207773638, 1.916e-07, 17.7657818472, 1.918e-07, 17.8129764197, 1.92e-07, 17.8623775133, 1.922e-07, 17.9140011653, 1.924e-07, 17.9678629907, 1.926e-07, 18.0239781513, 1.928e-07, 18.0823613234, 1.93e-07, 18.1430266625, 1.932e-07, 18.2059877654, 1.934e-07, 18.2712576302, 1.936e-07, 18.3388486129, 1.938e-07, 18.4087723818, 1.94e-07, 18.4810398692, 1.942e-07, 18.5556612193, 1.944e-07, 18.6326457341, 1.946e-07, 18.7120018161, 1.948e-07, 18.7937369076, 1.95e-07, 18.8778574271, 1.952e-07, 18.9643687027, 1.954e-07, 19.0532749022, 1.956e-07, 19.1445789601, 1.958e-07, 19.2382825016, 1.96e-07, 19.3343857628, 1.962e-07, 19.4328875087, 1.964e-07, 19.5337849474, 1.966e-07, 19.6370736415, 1.968e-07, 19.7427474166, 1.97e-07, 19.8507982667, 1.972e-07, 19.9612162571, 1.974e-07, 20.0739894244, 1.976e-07, 20.1891036743, 1.978e-07, 20.3065426768, 1.98e-07, 20.4262877596, 1.982e-07, 20.5483177995, 1.984e-07, 20.6726091122, 1.986e-07, 20.7991353414, 1.988e-07, 20.9278673459, 1.99e-07, 21.0587730871, 1.992e-07, 21.1918175162, 1.994e-07, 21.3269624613, 1.996e-07, 21.4641665159, 1.998e-07, 21.6033849286, 2e-07, 21.744569494, 2.002e-07, 21.8876684477, 2.004e-07, 22.0326263629, 2.006e-07, 22.1793840516, 2.008e-07, 22.327878471, 2.01e-07, 22.478042634, 2.012e-07, 22.6298055274, 2.014e-07, 22.7830920357, 2.016e-07, 22.9378228741, 2.018e-07, 23.0939145299, 2.02e-07, 23.2512792132, 2.022e-07, 23.4098248192, 2.024e-07, 23.5694549015, 2.026e-07, 23.7300686587, 2.028e-07, 23.8915609338, 2.03e-07, 24.0538222293, 2.032e-07, 24.2167387368, 2.034e-07, 24.3801923836, 2.036e-07, 24.5440608967, 2.038e-07, 24.7082178849, 2.04e-07, 24.8725329397, 2.042e-07, 25.0368717562, 2.044e-07, 25.201096274, 2.046e-07, 25.3650648393, 2.048e-07, 25.5286323882, 2.05e-07, 25.6916506515, 2.052e-07, 25.8539683814, 2.054e-07, 26.0154316004, 2.056e-07, 26.1758838715, 2.058e-07, 26.3351665902, 2.06e-07, 26.4931192981, 2.062e-07, 26.6495800162, 2.064e-07, 26.8043855985, 2.066e-07, 26.9573721047, 2.068e-07, 27.1083751899, 2.07e-07, 27.2572305112, 2.072e-07, 27.403774149, 2.074e-07, 27.5478430413, 2.076e-07, 27.6892754297, 2.078e-07, 27.827911314, 2.08e-07, 27.9635929142, 2.082e-07, 28.0961651372, 2.084e-07, 28.2254760457, 2.086e-07, 28.3513773263, 2.088e-07, 28.4737247554, 2.09e-07, 28.5923786584, 2.092e-07, 28.7072043606, 2.094e-07, 28.8180726277, 2.096e-07, 28.9248600905, 2.098e-07, 29.0274496544, 2.1e-07, 29.1257308881, 2.102e-07, 29.219600391, 2.104e-07, 29.3089621357, 2.106e-07, 29.3937277839, 2.108e-07, 29.4738169733, 2.11e-07, 29.5491575732, 2.112e-07, 29.6196859078, 2.114e-07, 29.6853469461, 2.116e-07, 29.7460944552, 2.118e-07, 29.8018911184, 2.12e-07, 29.8527086159, 2.122e-07, 29.8985276689, 2.124e-07, 29.9393380453, 2.126e-07, 29.9751385292, 2.128e-07, 30.0059368531, 2.13e-07, 30.0317495946, 2.132e-07, 30.0526020377, 2.134e-07, 30.0685280006, 2.136e-07, 30.0795696316, 2.138e-07, 30.0857771743, 2.14e-07, 30.0872087038, 2.142e-07, 30.0839298372, 2.144e-07, 30.0760134192, 2.146e-07, 30.0635391858, 2.148e-07, 30.046593409, 2.15e-07, 30.0252685233, 2.152e-07, 29.999662739, 2.154e-07, 29.9698796428, 2.156e-07, 29.9360277887, 2.158e-07, 29.898220283, 2.16e-07, 29.8565743639, 2.162e-07, 29.8112109792, 2.164e-07, 29.7622543649, 2.166e-07, 29.7098316251, 2.168e-07, 29.6540723175, 2.17e-07, 29.5951080446, 2.172e-07, 29.5330720533, 2.174e-07, 29.4680988446, 2.176e-07, 29.4003237939, 2.178e-07, 29.3298827849, 2.18e-07, 29.2569118569, 2.182e-07, 29.1815468667, 2.184e-07, 29.1039231665, 2.186e-07, 29.0241752981, 2.188e-07, 28.9424367041, 2.19e-07, 28.8588394562, 2.192e-07, 28.7735140013, 2.194e-07, 28.6865889255, 2.196e-07, 28.5981907353, 2.198e-07, 28.5084436572, 2.2e-07, 28.4174694538, 2.202e-07, 28.3253872584, 2.204e-07, 28.232313425, 2.206e-07, 28.1383613959, 2.208e-07, 28.0436415843, 2.21e-07, 27.9482612727, 2.212e-07, 27.8523245256, 2.214e-07, 27.7559321169, 2.216e-07, 27.6591814701, 2.218e-07, 27.5621666113, 2.22e-07, 27.4649781347, 2.222e-07, 27.3677031782, 2.224e-07, 27.2704254112, 2.226e-07, 27.1732250308, 2.228e-07, 27.0761787678, 2.23e-07, 26.9793599009, 2.232e-07, 26.8828382789, 2.234e-07, 26.7866803495, 2.236e-07, 26.6909491949, 2.238e-07, 26.5957045733, 2.24e-07, 26.5010029651, 2.242e-07, 26.406897624, 2.244e-07, 26.3134386322, 2.246e-07, 26.2206729595, 2.248e-07, 26.1286445246, 2.25e-07, 26.0373942597, 2.252e-07, 25.9469601777, 2.254e-07, 25.8573774396, 2.256e-07, 25.7686784255, 2.258e-07, 25.6808928046, 2.26e-07, 25.5940476079, 2.262e-07, 25.5081672995, 2.264e-07, 25.4232738497, 2.266e-07, 25.3393868076, 2.268e-07, 25.2565233725, 2.27e-07, 25.1746984668, 2.272e-07, 25.0939248067, 2.274e-07, 25.0142129728, 2.276e-07, 24.9355714799, 2.278e-07, 24.8580068461, 2.28e-07, 24.78152366, 2.282e-07, 24.7061246476, 2.284e-07, 24.6318107379, 2.286e-07, 24.558581127, 2.288e-07, 24.4864333408, 2.29e-07, 24.4153632975, 2.292e-07, 24.345365367, 2.294e-07, 24.2764324308, 2.296e-07, 24.2085559399, 2.298e-07, 24.1417259707, 2.3e-07, 24.0759312813, 2.302e-07, 24.011159365, 2.304e-07, 23.9473965038, 2.306e-07, 23.88462782, 2.308e-07, 23.8228373272, 2.31e-07, 23.7620079803, 2.312e-07, 23.7021217241, 2.314e-07, 23.6431595412, 2.316e-07, 23.5851014997, 2.318e-07, 23.5279267988, 2.32e-07, 23.471613815, 2.322e-07, 23.4161401466, 2.324e-07, 23.3614826585, 2.326e-07, 23.3076175257, 2.328e-07, 23.2545202768, 2.33e-07, 23.2021658369, 2.332e-07, 23.15052857, 2.334e-07, 23.0995823217, 2.336e-07, 23.0493004606, 2.338e-07, 22.9996559208, 2.34e-07, 22.9506212431, 2.342e-07, 22.9021686165, 2.344e-07, 22.8542699203, 2.346e-07, 22.8068967649, 2.348e-07, 22.7600205336, 2.35e-07, 22.7136124241, 2.352e-07, 22.6676434898, 2.354e-07, 22.6220846818, 2.356e-07, 22.5769068905, 2.358e-07, 22.5320809871, 2.36e-07, 22.4875778659, 2.362e-07, 22.4433684862, 2.364e-07, 22.3994239142, 2.366e-07, 22.3557153652, 2.368e-07, 22.3122142461, 2.37e-07, 22.2688921972, 2.372e-07, 22.2257211347, 2.374e-07, 22.1826732927, 2.376e-07, 22.1397212657, 2.378e-07, 22.0968380499, 2.38e-07, 22.0539970857, 2.382e-07, 22.0111722986, 2.384e-07, 21.9683381411, 2.386e-07, 21.9254696328, 2.388e-07, 21.8825424018, 2.39e-07, 21.8395327237, 2.392e-07, 21.7964175615, 2.394e-07, 21.753174604, 2.396e-07, 21.709782304, 2.398e-07, 21.6662199147, 2.4e-07, 21.6224675268, 2.402e-07, 21.5785061027, 2.404e-07, 21.5343175107, 2.406e-07, 21.4898845583, 2.408e-07, 21.445191023, 2.41e-07, 21.4002216824, 2.412e-07, 21.3549623436, 2.414e-07, 21.3093998692, 2.416e-07, 21.2635222033, 2.418e-07, 21.217318395, 2.42e-07, 21.1707786204, 2.422e-07, 21.1238942022, 2.424e-07, 21.0766576282, 2.426e-07, 21.0290625667, 2.428e-07, 20.9811038811, 2.43e-07, 20.9327776412, 2.432e-07, 20.8840811329, 2.434e-07, 20.8350128658, 2.436e-07, 20.7855725784, 2.438e-07, 20.7357612406, 2.44e-07, 20.6855810548, 2.442e-07, 20.6350354542, 2.444e-07, 20.5841290985, 2.446e-07, 20.5328678681, 2.448e-07, 20.4812588554, 2.45e-07, 20.429310354, 2.452e-07, 20.3770318463, 2.454e-07, 20.3244339879, 2.456e-07, 20.2715285906, 2.458e-07, 20.2183286034, 2.46e-07, 20.164848091, 2.462e-07, 20.1111022112, 2.464e-07, 20.0571071895, 2.466e-07, 20.0028802927, 2.468e-07, 19.9484398005, 2.47e-07, 19.893804976, 2.472e-07, 19.8389960341, 2.474e-07, 19.7840341091, 2.476e-07, 19.7289412206, 2.478e-07, 19.6737402391, 2.48e-07, 19.6184548497, 2.482e-07, 19.5631095154, 2.484e-07, 19.5077294399, 2.486e-07, 19.452340529, 2.488e-07, 19.3969693523, 2.49e-07, 19.3416431045, 2.492e-07, 19.2863895653, 2.494e-07, 19.2312370611, 2.496e-07, 19.1762144248, 2.498e-07, 19.121350957, 2.5e-07, 19.0666763867, 2.502e-07, 19.0122208328, 2.504e-07, 18.9580147656, 2.506e-07, 18.9040889693, 2.508e-07, 18.8504745047, 2.51e-07, 18.7972026728, 2.512e-07, 18.7443049792, 2.514e-07, 18.6918130995, 2.516e-07, 18.6397588456, 2.518e-07, 18.5881741328, 2.52e-07, 18.5370909482, 2.522e-07, 18.4865413206, 2.524e-07, 18.4365572908, 2.526e-07, 18.3871708837, 2.528e-07, 18.3384140816, 2.53e-07, 18.2903187989, 2.532e-07, 18.242916858, 2.534e-07, 18.1962399662, 2.536e-07, 18.1503196947, 2.538e-07, 18.1051874589, 2.54e-07, 18.0608744991, 2.542e-07, 18.0174118639, 2.544e-07, 17.974830394, 2.546e-07, 17.933160708, 2.548e-07, 17.892433189, 2.55e-07, 17.8526779733, 2.552e-07, 17.813924939, 2.554e-07, 17.7762036977, 2.556e-07, 17.7395435859, 2.558e-07, 17.7039736583, 2.56e-07, 17.6695226823, 2.562e-07, 17.6362191331, 2.564e-07, 17.6040911906, 2.566e-07, 17.5731667365, 2.568e-07, 17.5434733532, 2.57e-07, 17.5150383229, 2.572e-07, 17.4878886278, 2.574e-07, 17.4620509515, 2.576e-07, 17.4375516805, 2.578e-07, 17.4144169066, 2.58e-07, 17.3926724305, 2.582e-07, 17.3723437648, 2.584e-07, 17.3534561387, 2.586e-07, 17.3360345024, 2.588e-07, 17.320103532, 2.59e-07, 17.305687635, 2.592e-07, 17.2928109558, 2.594e-07, 17.2814973813, 2.596e-07, 17.271770547, 2.598e-07, 17.2636538426, 2.6e-07, 17.2571704184, 2.602e-07, 17.2523431907, 2.604e-07, 17.2491948474, 2.606e-07, 17.2477478541, 2.608e-07, 17.2480244587, 2.61e-07, 17.2500466969, 2.612e-07, 17.2538363959, 2.614e-07, 17.2594151792, 2.616e-07, 17.2668044695, 2.618e-07, 17.2760254921, 2.62e-07, 17.2870992766, 2.622e-07, 17.3000466586, 2.624e-07, 17.3148882807, 2.626e-07, 17.3316445915, 2.628e-07, 17.3503358452, 2.63e-07, 17.370982099, 2.632e-07, 17.39360321, 2.634e-07, 17.4182188309, 2.636e-07, 17.4448484038, 2.638e-07, 17.4735111539, 2.64e-07, 17.5042260809, 2.642e-07, 17.5370119489, 2.644e-07, 17.5718872757, 2.646e-07, 17.6088703191, 2.648e-07, 17.647979063, 2.65e-07, 17.6892312005, 2.652e-07, 17.732644116, 2.654e-07, 17.7782348646, 2.656e-07, 17.8260201506, 2.658e-07, 17.8760163025, 2.66e-07, 17.9282392471, 2.662e-07, 17.9827044809, 2.664e-07, 18.0394270387, 2.666e-07, 18.0984214605, 2.668e-07, 18.1597017556, 2.67e-07, 18.2232813643, 2.672e-07, 18.2891731164, 2.674e-07, 18.3573891883, 2.676e-07, 18.4279410553, 2.678e-07, 18.5008394434, 2.68e-07, 18.5760942763, 2.682e-07, 18.6537146202, 2.684e-07, 18.733708626, 2.686e-07, 18.8160834674, 2.688e-07, 18.900845277, 2.69e-07, 18.9879990784, 2.692e-07, 19.0775487157, 2.694e-07, 19.1694967794, 2.696e-07, 19.2638445298, 2.698e-07, 19.3605918163, 2.7e-07, 19.4597369946, 2.702e-07, 19.5612768399, 2.704e-07, 19.6652064576, 2.706e-07, 19.771519191, 2.708e-07, 19.880206526, 2.71e-07, 19.9912579933, 2.712e-07, 20.1046610677, 2.714e-07, 20.2204010649, 2.716e-07, 20.3384610369, 2.718e-07, 20.4588216642, 2.72e-07, 20.5814611469, 2.722e-07, 20.7063550945, 2.724e-07, 20.833476414, 2.726e-07, 20.9627951977, 2.728e-07, 21.0942786101, 2.73e-07, 21.2278907748, 2.732e-07, 21.3635926628, 2.734e-07, 21.5013419804, 2.736e-07, 21.6410930595, 2.738e-07, 21.7827967497, 2.74e-07, 21.9264003134, 2.742e-07, 22.0718473236, 2.744e-07, 22.2190775667, 2.746e-07, 22.3680269495, 2.748e-07, 22.5186274119, 2.75e-07, 22.6708068467, 2.752e-07, 22.8244890255, 2.754e-07, 22.979593534, 2.756e-07, 23.1360357154, 2.758e-07, 23.2937266251, 2.76e-07, 23.4525729949, 2.762e-07, 23.6124772101, 2.764e-07, 23.7733372995, 2.766e-07, 23.935046939, 2.768e-07, 24.0974954701, 2.77e-07, 24.2605679345, 2.772e-07, 24.4241451251, 2.774e-07, 24.5881036545, 2.776e-07, 24.7523160423, 2.778e-07, 24.9166508215, 2.78e-07, 25.0809726644, 2.782e-07, 25.2451425291, 2.784e-07, 25.4090178276, 2.786e-07, 25.5724526145, 2.788e-07, 25.7352977979, 2.79e-07, 25.8974013719, 2.792e-07, 26.0586086713, 2.794e-07, 26.2187626477, 2.796e-07, 26.3777041675, 2.798e-07, 26.5352723303, 2.8e-07, 26.6913048084, 2.802e-07, 26.8456382052, 2.804e-07, 26.9981084329, 2.806e-07, 27.1485511065, 2.808e-07, 27.2968019549, 2.81e-07, 27.4426972453, 2.812e-07, 27.5860742218, 2.814e-07, 27.7267715526, 2.816e-07, 27.8646297881, 2.818e-07, 27.9994918236, 2.82e-07, 28.1312033671, 2.822e-07, 28.259613408, 2.824e-07, 28.3845746855, 2.826e-07, 28.5059441521, 2.828e-07, 28.6235834314, 2.83e-07, 28.7373592668, 2.832e-07, 28.8471439569, 2.834e-07, 28.9528157778, 2.836e-07, 29.0542593859, 2.838e-07, 29.1513662023, 2.84e-07, 29.2440347731, 2.842e-07, 29.3321711051, 2.844e-07, 29.415688974, 2.846e-07, 29.4945102035, 2.848e-07, 29.5685649118, 2.85e-07, 29.6377917268, 2.852e-07, 29.7021379653, 2.854e-07, 29.761559778, 2.856e-07, 29.8160222568, 2.858e-07, 29.8654995062, 2.86e-07, 29.9099746767, 2.862e-07, 29.9494399611, 2.864e-07, 29.9838965537, 2.866e-07, 30.013354573, 2.868e-07, 30.0378329486, 2.87e-07, 30.0573592738, 2.872e-07, 30.0719696244, 2.874e-07, 30.0817083458, 2.876e-07, 30.086627811, 2.878e-07, 30.0867881491, 2.88e-07, 30.0822569492, 2.882e-07, 30.0731089397, 2.884e-07, 30.0594256469, 2.886e-07, 30.0412950341, 2.888e-07, 30.018811125, 2.89e-07, 29.9920736127, 2.892e-07, 29.9611874577, 2.894e-07, 29.9262624771, 2.896e-07, 29.8874129277, 2.898e-07, 29.844757085, 2.9e-07, 29.7984168209, 2.902e-07, 29.7485171821, 2.904e-07, 29.6951859721, 2.906e-07, 29.6385533373, 2.908e-07, 29.5787513604, 2.91e-07, 29.515913663, 2.912e-07, 29.4501750174, 2.914e-07, 29.381670971, 2.916e-07, 29.3105374833, 2.918e-07, 29.236910577, 2.92e-07, 29.1609260046, 2.922e-07, 29.08271893, 2.924e-07, 29.0024236276, 2.926e-07, 28.9201731979, 2.928e-07, 28.8360993006, 2.93e-07, 28.7503319058, 2.932e-07, 28.6629990618, 2.934e-07, 28.5742266822, 2.936e-07, 28.4841383493, 2.938e-07, 28.3928551356, 2.94e-07, 28.3004954422, 2.942e-07, 28.207174854, 2.944e-07, 28.1130060108, 2.946e-07, 28.018098495, 2.948e-07, 27.9225587331, 2.95e-07, 27.826489913, 2.952e-07, 27.7299919145, 2.954e-07, 27.6331612532, 2.956e-07, 27.5360910368, 2.958e-07, 27.4388709336, 2.96e-07, 27.3415871514, 2.962e-07, 27.2443224274, 2.964e-07, 27.1471560273, 2.966e-07, 27.0501637534, 2.968e-07, 26.9534179613, 2.97e-07, 26.8569875836, 2.972e-07, 26.760938161, 2.974e-07, 26.665331879, 2.976e-07, 26.5702276112, 2.978e-07, 26.4756809666, 2.98e-07, 26.3817443421, 2.982e-07, 26.2884669784, 2.984e-07, 26.1958950201, 2.986e-07, 26.1040715778, 2.988e-07, 26.0130367935, 2.99e-07, 25.9228279075, 2.992e-07, 25.8334793278, 2.994e-07, 25.7450226994, 2.996e-07, 25.6574869765, 2.998e-07, 25.5708984938, 3e-07, 25.4852810389, 3.002e-07, 25.4006559252, 3.004e-07, 25.3170420636, 3.006e-07, 25.2344560355, 3.008e-07, 25.1529121639, 3.01e-07, 25.0724225848, 3.012e-07, 24.9929973177, 3.014e-07, 24.9146443345, 3.016e-07, 24.8373696288, 3.018e-07, 24.7611772826, 3.02e-07, 24.6860695334, 3.022e-07, 24.6120468385, 3.024e-07, 24.5391079397, 3.026e-07, 24.4672499253, 3.028e-07, 24.3964682919, 3.03e-07, 24.3267570042, 3.032e-07, 24.2581085541, 3.034e-07, 24.190514018, 3.036e-07, 24.1239631131, 3.038e-07, 24.0584442526, 3.04e-07, 23.9939445997, 3.042e-07, 23.9304501198, 3.044e-07, 23.8679456328, 3.046e-07, 23.8064148632, 3.048e-07, 23.7458404899, 3.05e-07, 23.6862041949, 3.052e-07, 23.6274867107, 3.054e-07, 23.5696678674, 3.056e-07, 23.5127266392, 3.058e-07, 23.4566411892, 3.06e-07, 23.4013889145, 3.062e-07, 23.3469464905, 3.064e-07, 23.2932899145, 3.066e-07, 23.2403945489, 3.068e-07, 23.1882351639, 3.07e-07, 23.1367859803, 3.072e-07, 23.0860207115, 3.074e-07, 23.0359126054, 3.076e-07, 22.9864344864, 3.078e-07, 22.9375587969, 3.08e-07, 22.8892576386, 3.082e-07, 22.8415028145, 3.084e-07, 22.79426587, 3.086e-07, 22.7475181345, 3.088e-07, 22.7012307629, 3.09e-07, 22.655374777, 3.092e-07, 22.6099211077, 3.094e-07, 22.5648406358, 3.096e-07, 22.5201042349, 3.098e-07, 22.4756828125, 3.1e-07, 22.4315473524, 3.102e-07, 22.3876689568, 3.104e-07, 22.3440188882, 3.106e-07, 22.300568612, 3.108e-07, 22.2572898384, 3.11e-07, 22.2141545649, 3.112e-07, 22.1711351182, 3.114e-07, 22.1282041964, 3.116e-07, 22.085334911, 3.118e-07, 22.0425008284, 3.12e-07, 21.9996760116, 3.122e-07, 21.9568350613, 3.124e-07, 21.9139531567, 3.126e-07, 21.8710060955, 3.128e-07, 21.8279703341, 3.13e-07, 21.7848230267, 3.132e-07, 21.7415420633, 3.134e-07, 21.6981061081, 3.136e-07, 21.6544946356, 3.138e-07, 21.6106879669, 3.14e-07, 21.5666673046, 3.142e-07, 21.5224147658, 3.144e-07, 21.4779134152, 3.146e-07, 21.4331472961, 3.148e-07, 21.3881014597, 3.15e-07, 21.3427619937, 3.152e-07, 21.2971160486, 3.154e-07, 21.251151863, 3.156e-07, 21.2048587864, 3.158e-07, 21.1582273008, 3.16e-07, 21.11124904, 3.162e-07, 21.0639168072, 3.164e-07, 21.0162245902, 3.166e-07, 20.9681675751, 3.168e-07, 20.9197421574, 3.17e-07, 20.8709459508, 3.172e-07, 20.8217777945, 3.174e-07, 20.7722377571, 3.176e-07, 20.7223271397, 3.178e-07, 20.6720484751, 3.18e-07, 20.6214055263, 3.182e-07, 20.5704032814, 3.184e-07, 20.519047947, 3.186e-07, 20.4673469391, 3.188e-07, 20.415308872, 3.19e-07, 20.3629435443, 3.192e-07, 20.3102619238, 3.194e-07, 20.2572761296, 3.196e-07, 20.2039994123, 3.198e-07, 20.1504461325, 3.2e-07, 20.096631737, 3.202e-07, 20.0425727336, 3.204e-07, 19.9882866637, 3.206e-07, 19.9337920741, 3.208e-07, 19.8791084865, 3.21e-07, 19.8242563658, 3.212e-07, 19.7692570873, 3.214e-07, 19.7141329026, 3.216e-07, 19.6589069044, 3.218e-07, 19.6036029902, 3.22e-07, 19.5482458255, 3.222e-07, 19.4928608063, 3.224e-07, 19.4374740204, 3.226e-07, 19.3821122091, 3.228e-07, 19.3268027278, 3.23e-07, 19.271573507, 3.232e-07, 19.2164530129, 3.234e-07, 19.1614702078, 3.236e-07, 19.106654511, 3.238e-07, 19.0520357601, 3.24e-07, 18.997644172, 3.242e-07, 18.943510305, 3.244e-07, 18.8896650211, 3.246e-07, 18.8361394491, 3.248e-07, 18.7829649483, 3.25e-07, 18.7301730736, 3.252e-07, 18.6777955402, 3.254e-07, 18.625864191, 3.256e-07, 18.5744109637, 3.258e-07, 18.5234678594, 3.26e-07, 18.4730669131, 3.262e-07, 18.4232401638, 3.264e-07, 18.3740196278, 3.266e-07, 18.3254372715, 3.268e-07, 18.2775249869, 3.27e-07, 18.2303145676, 3.272e-07, 18.1838376865, 3.274e-07, 18.138125875, 3.276e-07, 18.093210503, 3.278e-07, 18.0491227611, 3.28e-07, 18.0058936437, 3.282e-07, 17.963553933, 3.284e-07, 17.9221341859, 3.286e-07, 17.8816647202, 3.288e-07, 17.8421756037, 3.29e-07, 17.8036966442, 3.292e-07, 17.7662573799, 3.294e-07, 17.7298870724, 3.296e-07, 17.6946146998, 3.298e-07, 17.6604689514, 3.3e-07, 17.6274782234, 3.302e-07, 17.5956706159, 3.304e-07, 17.5650739305, 3.306e-07, 17.5357156688, 3.308e-07, 17.5076230325, 3.31e-07, 17.4808229236, 3.312e-07, 17.4553419456, 3.314e-07, 17.4312064057, 3.316e-07, 17.4084423173, 3.318e-07, 17.3870754033, 3.32e-07, 17.3671310998, 3.322e-07, 17.3486345606, 3.324e-07, 17.3316106618, 3.326e-07, 17.316084007, 3.328e-07, 17.3020789325, 3.33e-07, 17.2896195128, 3.332e-07, 17.278729567, 3.334e-07, 17.2694326639, 3.336e-07, 17.2617521284, 3.338e-07, 17.2557110474, 3.34e-07, 17.2513322752, 3.342e-07, 17.2486384398, 3.344e-07, 17.2476519476, 3.346e-07, 17.2483949892, 3.348e-07, 17.2508895438, 3.35e-07, 17.2551573837, 3.352e-07, 17.2612200781, 3.354e-07, 17.2690989964, 3.356e-07, 17.2788153112, 3.358e-07, 17.29039, 3.36e-07, 17.3038438466, 3.362e-07, 17.3191974413, 3.364e-07, 17.3364711809, 3.366e-07, 17.355685267, 3.368e-07, 17.3768597034, 3.37e-07, 17.4000142928, 3.372e-07, 17.4251686319, 3.374e-07, 17.4523421054, 3.376e-07, 17.4815538789, 3.378e-07, 17.5128228898, 3.38e-07, 17.5461678373, 3.382e-07, 17.5816071706, 3.384e-07, 17.6191590758, 3.386e-07, 17.6588414601, 3.388e-07, 17.7006719358, 3.39e-07, 17.7446678009, 3.392e-07, 17.7908460186, 3.394e-07, 17.8392231947, 3.396e-07, 17.8898155527, 3.398e-07, 17.9426389068, 3.4e-07, 17.9977086326, 3.402e-07, 18.0550396355, 3.404e-07, 18.1146463166, 3.406e-07, 18.1765425365, 3.408e-07, 18.2407415756, 3.41e-07, 18.3072560929, 3.412e-07, 18.376098081, 3.414e-07, 18.4472788193, 3.416e-07, 18.5208088236, 3.418e-07, 18.5966977929, 3.42e-07, 18.6749545536, 3.422e-07, 18.7555870004, 3.424e-07, 18.838602034, 3.426e-07, 18.9240054961, 3.428e-07, 19.0118021007, 3.43e-07, 19.1019953628, 3.432e-07, 19.1945875236, 3.434e-07, 19.2895794725, 3.436e-07, 19.3869706665, 3.438e-07, 19.4867590453, 3.44e-07, 19.5889409449, 3.442e-07, 19.693511007, 3.444e-07, 19.8004620857, 3.446e-07, 19.9097851519, 3.448e-07, 20.0214691941, 3.45e-07, 20.135501118, 3.452e-07, 20.2518656419, 3.454e-07, 20.3705451919, 3.456e-07, 20.4915197934, 3.458e-07, 20.614766962, 3.46e-07, 20.7402615928, 3.462e-07, 20.8679758483, 3.464e-07, 20.9978790458, 3.466e-07, 21.1299375446, 3.468e-07, 21.2641146333, 3.47e-07, 21.4003704172, 3.472e-07, 21.5386617076, 3.474e-07, 21.678941912, 3.476e-07, 21.8211609274, 3.478e-07, 21.9652650356, 3.48e-07, 22.1111968025, 3.482e-07, 22.258894982, 3.484e-07, 22.4082944243, 3.486e-07, 22.5593259907, 3.488e-07, 22.7119164744, 3.49e-07, 22.8659885295, 3.492e-07, 23.021460608, 3.494e-07, 23.1782469062, 3.496e-07, 23.3362573217, 3.498e-07, 23.4953974214, 3.5e-07, 23.6555684215, 3.502e-07, 23.8166671815, 3.504e-07, 23.9785862112, 3.506e-07, 24.141213694, 3.508e-07, 24.3044335252, 3.51e-07, 24.468125368, 3.512e-07, 24.632164727, 3.514e-07, 24.7964230406, 3.516e-07, 24.9607677919, 3.518e-07, 25.125062641, 3.52e-07, 25.289167577, 3.522e-07, 25.4529390909, 3.524e-07, 25.6162303712, 3.526e-07, 25.77889152, 3.528e-07, 25.9407697916, 3.53e-07, 26.1017098532, 3.532e-07, 26.2615540663, 3.534e-07, 26.4201427911, 3.536e-07, 26.5773147097, 3.538e-07, 26.7329071717, 3.54e-07, 26.886756557, 3.542e-07, 27.0386986586, 3.544e-07, 27.1885690812, 3.546e-07, 27.3362036558, 3.548e-07, 27.4814388686, 3.55e-07, 27.6241123013, 3.552e-07, 27.7640630823, 3.554e-07, 27.9011323458, 3.556e-07, 28.035163696, 3.558e-07, 28.1660036758, 3.56e-07, 28.2935022353, 3.562e-07, 28.4175131992, 3.564e-07, 28.5378947296, 3.566e-07, 28.6545097807, 3.568e-07, 28.7672265449, 3.57e-07, 28.8759188847, 3.572e-07, 28.9804667499, 3.574e-07, 29.0807565763, 3.576e-07, 29.176681663, 3.578e-07, 29.268142527, 3.58e-07, 29.3550472315, 3.582e-07, 29.4373116865, 3.584e-07, 29.5148599192, 3.586e-07, 29.5876243127, 3.588e-07, 29.6555458109, 3.59e-07, 29.7185740894, 3.592e-07, 29.7766676899, 3.594e-07, 29.8297941182, 3.596e-07, 29.8779299053, 3.598e-07, 29.9210606309, 3.6e-07, 29.9591809098, 3.602e-07, 29.9922943408, 3.604e-07, 30.0204134203, 3.606e-07, 30.0435594195, 3.608e-07, 30.0617622276, 3.61e-07, 30.0750601626, 3.612e-07, 30.0834997498, 3.614e-07, 30.0871354719, 3.616e-07, 30.0860294908, 3.618e-07, 30.0802513443, 3.62e-07, 30.06987762, 3.622e-07, 30.0549916083, 3.624e-07, 30.035682937, 3.626e-07, 30.0120471904, 3.628e-07, 29.9841855156, 3.63e-07, 29.9522042173, 3.632e-07, 29.9162143457, 3.634e-07, 29.8763312778, 3.636e-07, 29.8326742957, 3.638e-07, 29.785366165, 3.64e-07, 29.7345327134, 3.642e-07, 29.6803024137, 3.644e-07, 29.6228059714, 3.646e-07, 29.5621759213, 3.648e-07, 29.4985462313, 3.65e-07, 29.4320519181, 3.652e-07, 29.3628286749, 3.654e-07, 29.2910125119, 3.656e-07, 29.2167394113, 3.658e-07, 29.140144998, 3.66e-07, 29.0613642261, 3.662e-07, 28.9805310821, 3.664e-07, 28.8977783053, 3.666e-07, 28.8132371255, 3.668e-07, 28.7270370188, 3.67e-07, 28.6393054809, 3.672e-07, 28.5501678179, 3.674e-07, 28.4597469554, 3.676e-07, 28.3681632639, 3.678e-07, 28.2755344021, 3.68e-07, 28.1819751762, 3.682e-07, 28.0875974159, 3.684e-07, 27.9925098653, 3.686e-07, 27.8968180891, 3.688e-07, 27.8006243934, 3.69e-07, 27.70402776, 3.692e-07, 27.6071237935, 3.694e-07, 27.5100046809, 3.696e-07, 27.4127591633, 3.698e-07, 27.3154725173, 3.7e-07, 27.218226548, 3.702e-07, 27.1210995902, 3.704e-07, 27.0241665191, 3.706e-07, 26.9274987688, 3.708e-07, 26.8311643579, 3.71e-07, 26.7352279228, 3.712e-07, 26.6397507555, 3.714e-07, 26.5447908483, 3.716e-07, 26.4504029427, 3.718e-07, 26.3566385826, 3.72e-07, 26.2635461717, 3.722e-07, 26.1711710339, 3.724e-07, 26.0795554764, 3.726e-07, 25.9887388557, 3.728e-07, 25.8987576449, 3.73e-07, 25.8096455033, 3.732e-07, 25.7214333467, 3.734e-07, 25.634149419, 3.736e-07, 25.547819364, 3.738e-07, 25.4624662981, 3.74e-07, 25.3781108826, 3.742e-07, 25.294771396, 3.744e-07, 25.2124638065, 3.746e-07, 25.1312018431, 3.748e-07, 25.0509970668, 3.75e-07, 24.9718589405, 3.752e-07, 24.8937948985, 3.754e-07, 24.8168104146, 3.756e-07, 24.7409090693, 3.758e-07, 24.6660926158, 3.76e-07, 24.5923610447, 3.762e-07, 24.5197126479, 3.764e-07, 24.4481440804, 3.766e-07, 24.3776504217, 3.768e-07, 24.3082252355, 3.77e-07, 24.2398606281, 3.772e-07, 24.1725473055, 3.774e-07, 24.1062746297, 3.776e-07, 24.0410306729, 3.778e-07, 23.9768022717, 3.78e-07, 23.913575079, 3.782e-07, 23.8513336157, 3.784e-07, 23.7900613209, 3.786e-07, 23.729740601, 3.788e-07, 23.6703528786, 3.79e-07, 23.6118786393, 3.792e-07, 23.554297479, 3.794e-07, 23.4975881497, 3.796e-07, 23.4417286045, 3.798e-07, 23.3866960426, 3.8e-07, 23.3324669529, 3.802e-07, 23.2790171581, 3.804e-07, 23.2263218574, 3.806e-07, 23.1743556695, 3.808e-07, 23.1230926748, 3.81e-07, 23.0725064576, 3.812e-07, 23.0225701481, 3.814e-07, 22.9732564639, 3.816e-07, 22.924537752, 3.818e-07, 22.8763860299, 3.82e-07, 22.8287730273, 3.822e-07, 22.7816702275, 3.824e-07, 22.7350489091, 3.826e-07, 22.688880187, 3.828e-07, 22.6431350548, 3.83e-07, 22.5977844255, 3.832e-07, 22.5527991742, 3.834e-07, 22.5081501792, 3.836e-07, 22.4638083644, 3.838e-07, 22.4197447414, 3.84e-07, 22.3759304511, 3.842e-07, 22.3323368065, 3.844e-07, 22.2889353344, 3.846e-07, 22.2456978182, 3.848e-07, 22.2025963394, 3.85e-07, 22.1596033204, 3.852e-07, 22.116691566, 3.854e-07, 22.073834306, 3.856e-07, 22.0310052358, 3.858e-07, 21.9881785588, 3.86e-07, 21.9453290271, 3.862e-07, 21.9024319818, 3.864e-07, 21.8594633937, 3.866e-07, 21.8163999026, 3.868e-07, 21.7732188565, 3.87e-07, 21.7298983496, 3.872e-07, 21.68641726, 3.874e-07, 21.642755286, 3.876e-07, 21.598892982, 3.878e-07, 21.5548117926, 3.88e-07, 21.5104940864, 3.882e-07, 21.4659231878, 3.884e-07, 21.4210834076, 3.886e-07, 21.3759600726, 3.888e-07, 21.3305395533, 3.89e-07, 21.28480929, 3.892e-07, 21.2387578171, 3.894e-07, 21.1923747863, 3.896e-07, 21.1456509868, 3.898e-07, 21.0985783646, 3.9e-07, 21.0511500397, 3.902e-07, 21.0033603202, 3.904e-07, 20.9552047159, 3.906e-07, 20.9066799484, 3.908e-07, 20.8577839599, 3.91e-07, 20.8085159192, 3.912e-07, 20.7588762257, 3.914e-07, 20.7088665111, 3.916e-07, 20.6584896389, 3.918e-07, 20.6077497013, 3.92e-07, 20.5566520145, 3.922e-07, 20.5052031106, 3.924e-07, 20.4534107284, 3.926e-07, 20.4012838016, 3.928e-07, 20.3488324443, 3.93e-07, 20.2960679351, 3.932e-07, 20.243002699, 3.934e-07, 20.1896502866, 3.936e-07, 20.1360253526, 3.938e-07, 20.0821436311, 3.94e-07, 20.02802191, 3.942e-07, 19.9736780037, 3.944e-07, 19.9191307236, 3.946e-07, 19.8643998477, 3.948e-07, 19.8095060887, 3.95e-07, 19.7544710604, 3.952e-07, 19.6993172437, 3.954e-07, 19.6440679509, 3.956e-07, 19.5887472894, 3.958e-07, 19.5333801245, 3.96e-07, 19.4779920417, 3.962e-07, 19.422609308, 3.964e-07, 19.3672588334, 3.966e-07, 19.3119681316, 3.968e-07, 19.2567652806, 3.97e-07, 19.2016788838, 3.972e-07, 19.1467380299, 3.974e-07, 19.0919722545, 3.976e-07, 19.0374115005, 3.978e-07, 18.9830860804, 3.98e-07, 18.9290266376, 3.982e-07, 18.8752641094, 3.984e-07, 18.8218296898, 3.986e-07, 18.7687547943, 3.988e-07, 18.7160710239, 3.99e-07, 18.6638101316, 3.992e-07, 18.6120039887, 3.994e-07, 18.5606845529, 3.996e-07, 18.5098838375, 3.998e-07, 18.4596338813, 4e-07, 18.4099667198, 4.002e-07, 18.3609143584, 4.004e-07, 18.3125087461, 4.006e-07, 18.2647817506, 4.008e-07, 18.2177651354, 4.01e-07, 18.1714905373, 4.012e-07, 18.1259894462, 4.014e-07, 18.0812931857, 4.016e-07, 18.0374328953, 4.018e-07, 17.9944395137, 4.02e-07, 17.9523437643, 4.022e-07, 17.9111761408, 4.024e-07, 17.8709668949, 4.026e-07, 17.8317460258, 4.028e-07, 17.7935432695, 4.03e-07, 17.7563880909, 4.032e-07, 17.7203096758, 4.034e-07, 17.6853369254, 4.036e-07, 17.6514984508, 4.038e-07, 17.6188225689, 4.04e-07, 17.5873372998, 4.042e-07, 17.5570703646, 4.044e-07, 17.5280491846, 4.046e-07, 17.5003008809, 4.048e-07, 17.4738522752, 4.05e-07, 17.4487298912, 4.052e-07, 17.4249599569, 4.054e-07, 17.4025684075, 4.056e-07, 17.3815808884, 4.058e-07, 17.3620227596, 4.06e-07, 17.3439190998, 4.062e-07, 17.3272947115, 4.064e-07, 17.3121741259, 4.066e-07, 17.2985816085, 4.068e-07, 17.2865411648, 4.07e-07, 17.2760765459, 4.072e-07, 17.2672112547, 4.074e-07, 17.2599685517, 4.076e-07, 17.2543714606, 4.078e-07, 17.2504427745, 4.08e-07, 17.2482050614, 4.082e-07, 17.2476806694, 4.084e-07, 17.2488917317, 4.086e-07, 17.2518601716, 4.088e-07, 17.2566077066, 4.09e-07, 17.2631558519, 4.092e-07, 17.2715259239, 4.094e-07, 17.2817390425, 4.096e-07, 17.2938161333, 4.098e-07, 17.307777928, 4.1e-07, 17.3236449652, 4.102e-07, 17.3414375893, 4.104e-07, 17.3611759493, 4.106e-07, 17.3828799952, 4.108e-07, 17.4065694751, 4.11e-07, 17.4322639293, 4.112e-07, 17.4599826846, 4.114e-07, 17.489744846, 4.116e-07, 17.5215692883, 4.118e-07, 17.5554746448, 4.12e-07, 17.5914792953, 4.122e-07, 17.6296013526, 4.124e-07, 17.6698586466, 4.126e-07, 17.712268707, 4.128e-07, 17.7568487442, 4.13e-07, 17.8036156277, 4.132e-07, 17.8525858631, 4.134e-07, 17.903775567, 4.136e-07, 17.9572004386, 4.138e-07, 18.0128757306, 4.14e-07, 18.0708162165, 4.142e-07, 18.131036156, 4.144e-07, 18.1935492579, 4.146e-07, 18.2583686399, 4.148e-07, 18.3255067866, 4.15e-07, 18.3949755041, 4.152e-07, 18.4667858718, 4.154e-07, 18.5409481914, 4.156e-07, 18.6174719334, 4.158e-07, 18.6963656801, 4.16e-07, 18.7776370656, 4.162e-07, 18.8612927128, 4.164e-07, 18.9473381674, 4.166e-07, 19.035777829, 4.168e-07, 19.1266148778, 4.17e-07, 19.2198512002, 4.172e-07, 19.315487309, 4.174e-07, 19.4135222623, 4.176e-07, 19.5139535782, 4.178e-07, 19.6167771466, 4.18e-07, 19.7219871387, 4.182e-07, 19.8295759127, 4.184e-07, 19.939533917, 4.186e-07, 20.0518495912, 4.188e-07, 20.166509264, 4.19e-07, 20.2834970489, 4.192e-07, 20.4027947382, 4.194e-07, 20.5243816943, 4.196e-07, 20.6482347404, 4.198e-07, 20.7743280491, 4.2e-07, 20.9026330302, 4.202e-07, 21.033118218, 4.204e-07, 21.1657491587, 4.206e-07, 21.3004882972, 4.208e-07, 21.4372948655, 4.21e-07, 21.5761247719, 4.212e-07, 21.7169304919, 4.214e-07, 21.8596609622, 4.216e-07, 22.0042614768, 4.218e-07, 22.1506735876, 4.22e-07, 22.2988350094, 4.222e-07, 22.4486795298, 4.224e-07, 22.6001369253, 4.226e-07, 22.7531328849, 4.228e-07, 22.9075889404, 4.23e-07, 23.0634224063, 4.232e-07, 23.2205463288, 4.234e-07, 23.3788694455, 4.236e-07, 23.5382961569, 4.238e-07, 23.6987265099, 4.24e-07, 23.8600561948, 4.242e-07, 24.0221765573, 4.244e-07, 24.1849746251, 4.246e-07, 24.3483331513, 4.248e-07, 24.5121306749, 4.25e-07, 24.6762415991, 4.252e-07, 24.8405362887, 4.254e-07, 25.0048811869, 4.256e-07, 25.1691389524, 4.258e-07, 25.3331686175, 4.26e-07, 25.4968257667, 4.262e-07, 25.6599627377, 4.264e-07, 25.8224288438, 4.266e-07, 25.9840706186, 4.268e-07, 26.1447320814, 4.27e-07, 26.3042550261, 4.272e-07, 26.4624793296, 4.274e-07, 26.6192432818, 4.276e-07, 26.7743839353, 4.278e-07, 26.9277374744, 4.28e-07, 27.0791396016, 4.282e-07, 27.228425941, 4.284e-07, 27.375432457, 4.286e-07, 27.5199958859, 4.288e-07, 27.6619541802, 4.29e-07, 27.8011469613, 4.292e-07, 27.9374159806, 4.294e-07, 28.070605585, 4.296e-07, 28.2005631861, 4.298e-07, 28.3271397284, 4.3e-07, 28.4501901558, 4.302e-07, 28.5695738722, 4.304e-07, 28.6851551949, 4.306e-07, 28.7968037963, 4.308e-07, 28.9043951329, 4.31e-07, 29.0078108572, 4.312e-07, 29.1069392112, 4.314e-07, 29.2016753978, 4.316e-07, 29.2919219285, 4.318e-07, 29.3775889446, 4.32e-07, 29.4585945099, 4.322e-07, 29.5348648725, 4.324e-07, 29.6063346946, 4.326e-07, 29.672947249, 4.328e-07, 29.7346545795, 4.33e-07, 29.791417626, 4.332e-07, 29.8432063125, 4.334e-07, 29.8899995983, 4.336e-07, 29.9317854913, 4.338e-07, 29.9685610245, 4.34e-07, 30.0003321951, 4.342e-07, 30.0271138685, 4.344e-07, 30.048929646, 4.346e-07, 30.0658116994, 4.348e-07, 30.0778005727, 4.35e-07, 30.0849449532, 4.352e-07, 30.0873014132, 4.354e-07, 30.0849341254, 4.356e-07, 30.077914553, 4.358e-07, 30.0663211177, 4.36e-07, 30.0502388477, 4.362e-07, 30.0297590076, 4.364e-07, 30.0049787143, 4.366e-07, 29.9760005394, 4.368e-07, 29.9429321023, 4.37e-07, 29.9058856559, 4.372e-07, 29.8649776669, 4.374e-07, 29.8203283941, 4.376e-07, 29.7720614662, 4.378e-07, 29.7203034616, 4.38e-07, 29.6651834927, 4.382e-07, 29.6068327955, 4.384e-07, 29.5453843277, 4.386e-07, 29.4809723762, 4.388e-07, 29.4137321753, 4.39e-07, 29.343799538, 4.392e-07, 29.2713105, 4.394e-07, 29.1964009796, 4.396e-07, 29.1192064517, 4.398e-07, 29.0398616389, 4.4e-07, 28.9585002198, 4.402e-07, 28.8752545534, 4.404e-07, 28.7902554221, 4.406e-07, 28.7036317918, 4.408e-07, 28.6155105903, 4.41e-07, 28.5260165028, 4.412e-07, 28.4352717853, 4.414e-07, 28.343396095, 4.416e-07, 28.2505063382, 4.418e-07, 28.1567165336, 4.42e-07, 28.0621376925, 4.422e-07, 27.9668777143, 4.424e-07, 27.8710412961, 4.426e-07, 27.7747298577, 4.428e-07, 27.6780414787, 4.43e-07, 27.58107085, 4.432e-07, 27.4839092359, 4.434e-07, 27.3866444487, 4.436e-07, 27.2893608337, 4.438e-07, 27.1921392636, 4.44e-07, 27.0950571434, 4.442e-07, 26.9981884224, 4.444e-07, 26.9016036149, 4.446e-07, 26.8053698283, 4.448e-07, 26.7095507971, 4.45e-07, 26.614206923, 4.452e-07, 26.5193953207, 4.454e-07, 26.4251698678, 4.456e-07, 26.3315812597, 4.458e-07, 26.2386770673, 4.46e-07, 26.1465017982, 4.462e-07, 26.0550969611, 4.464e-07, 25.9645011318, 4.466e-07, 25.8747500211, 4.468e-07, 25.785876545, 4.47e-07, 25.697910895, 4.472e-07, 25.6108806099, 4.474e-07, 25.524810648, 4.476e-07, 25.4397234594, 4.478e-07, 25.3556390589, 4.48e-07, 25.2725750976, 4.482e-07, 25.1905469356, 4.484e-07, 25.1095677131, 4.486e-07, 25.0296484209, 4.488e-07, 24.9507979708, 4.49e-07, 24.873023264, 4.492e-07, 24.7963292596, 4.494e-07, 24.7207190411, 4.496e-07, 24.6461938823, 4.498e-07, 24.5727533116, 4.5e-07, 24.5003951754, 4.502e-07, 24.4291156999, 4.504e-07, 24.3589095518, 4.506e-07, 24.289769898, 4.508e-07, 24.2216884632, 4.51e-07, 24.1546555874, 4.512e-07, 24.0886602808, 4.514e-07, 24.0236902788, 4.516e-07, 23.9597320953, 4.518e-07, 23.8967710741, 4.52e-07, 23.8347914409, 4.522e-07, 23.7737763528, 4.524e-07, 23.7137079475, 4.526e-07, 23.6545673912, 4.528e-07, 23.5963349263, 4.53e-07, 23.5389899177, 4.532e-07, 23.4825108983, 4.534e-07, 23.4268756148, 4.536e-07, 23.3720610711, 4.538e-07, 23.3180435733, 4.54e-07, 23.2647987724, 4.542e-07, 23.2123017075, 4.544e-07, 23.1605268488, 4.546e-07, 23.1094481392, 4.548e-07, 23.0590390372, 4.55e-07, 23.0092725581, 4.552e-07, 22.9601213159, 4.554e-07, 22.9115575651, 4.556e-07, 22.8635532418, 4.558e-07, 22.8160800055, 4.56e-07, 22.7691092806, 4.562e-07, 22.7226122976, 4.564e-07, 22.6765601348, 4.566e-07, 22.6309237599, 4.568e-07, 22.5856740718, 4.57e-07, 22.5407819423, 4.572e-07, 22.4962182578, 4.574e-07, 22.4519539616, 4.576e-07, 22.4079600958, 4.578e-07, 22.3642078436, 4.58e-07, 22.3206685709, 4.582e-07, 22.2773138696, 4.584e-07, 22.2341155987, 4.586e-07, 22.1910459271, 4.588e-07, 22.1480773759, 4.59e-07, 22.1051828598, 4.592e-07, 22.0623357294, 4.594e-07, 22.0195098126, 4.596e-07, 21.9766794559, 4.598e-07, 21.9338195656, 4.6e-07, 21.8909056479, 4.602e-07, 21.8479138494, 4.604e-07, 21.8048209961, 4.606e-07, 21.7616046327, 4.608e-07, 21.7182430601, 4.61e-07, 21.674715373, 4.612e-07, 21.6310014961, 4.614e-07, 21.5870822194, 4.616e-07, 21.5429392323, 4.618e-07, 21.498555157, 4.62e-07, 21.4539135795, 4.622e-07, 21.4089990807, 4.624e-07, 21.363797265, 4.626e-07, 21.3182947873, 4.628e-07, 21.2724793794, 4.63e-07, 21.2263398735, 4.632e-07, 21.1798662245, 4.634e-07, 21.1330495306, 4.636e-07, 21.0858820513, 4.638e-07, 21.038357224, 4.64e-07, 20.9904696784, 4.642e-07, 20.9422152486, 4.644e-07, 20.8935909831, 4.646e-07, 20.8445951527, 4.648e-07, 20.7952272564, 4.65e-07, 20.7454880243, 4.652e-07, 20.695379419, 4.654e-07, 20.644904634, 4.656e-07, 20.5940680908, 4.658e-07, 20.5428754328, 4.66e-07, 20.491333517, 4.662e-07, 20.4394504044, 4.664e-07, 20.3872353468, 4.666e-07, 20.3346987727, 4.668e-07, 20.2818522703, 4.67e-07, 20.2287085688, 4.672e-07, 20.1752815175, 4.674e-07, 20.1215860632, 4.676e-07, 20.0676382255, 4.678e-07, 20.0134550707, 4.68e-07, 19.9590546836, 4.682e-07, 19.9044561383, 4.684e-07, 19.8496794669, 4.686e-07, 19.7947456271, 4.688e-07, 19.7396764691, 4.69e-07, 19.6844947005, 4.692e-07, 19.6292238505, 4.694e-07, 19.5738882337, 4.696e-07, 19.5185129125, 4.698e-07, 19.463123659, 4.7e-07, 19.4077469168, 4.702e-07, 19.3524097617, 4.704e-07, 19.2971398628, 4.706e-07, 19.241965443, 4.708e-07, 19.1869152398, 4.71e-07, 19.1320184657, 4.712e-07, 19.0773047694, 4.714e-07, 19.0228041969, 4.716e-07, 18.9685471531, 4.718e-07, 18.914564364, 4.72e-07, 18.8608868394, 4.722e-07, 18.8075458363, 4.724e-07, 18.7545728232, 4.726e-07, 18.7019994455, 4.728e-07, 18.6498574909, 4.73e-07, 18.5981788573, 4.732e-07, 18.5469955201, 4.734e-07, 18.4963395024, 4.736e-07, 18.4462428447, 4.738e-07, 18.3967375774, 4.74e-07, 18.347855693, 4.742e-07, 18.2996291211, 4.744e-07, 18.2520897038, 4.746e-07, 18.2052691724, 4.748e-07, 18.1591991265, 4.75e-07, 18.1139110131, 4.752e-07, 18.069436108, 4.754e-07, 18.0258054985, 4.756e-07, 17.9830500668, 4.758e-07, 17.941200476, 4.76e-07, 17.900287156, 4.762e-07, 17.8603402918, 4.764e-07, 17.8213898128, 4.766e-07, 17.783465383, 4.768e-07, 17.746596393, 4.77e-07, 17.710811953, 4.772e-07, 17.6761408866, 4.774e-07, 17.6426117262, 4.776e-07, 17.6102527094, 4.778e-07, 17.5790917763, 4.78e-07, 17.5491565674, 4.782e-07, 17.5204744234, 4.784e-07, 17.4930723849, 4.786e-07, 17.4669771936, 4.788e-07, 17.4422152935, 4.79e-07, 17.4188128337, 4.792e-07, 17.3967956712, 4.794e-07, 17.3761893744, 4.796e-07, 17.3570192274, 4.798e-07, 17.3393102342, 4.8e-07, 17.3230871239, 4.802e-07, 17.308374356, 4.804e-07, 17.2951961256, 4.806e-07, 17.2835763692, 4.808e-07, 17.2735387708, 4.81e-07, 17.2651067676, 4.812e-07, 17.258303556, 4.814e-07, 17.2531520973, 4.816e-07, 17.2496751235, 4.818e-07, 17.2478951431, 4.82e-07, 17.2478344461, 4.822e-07, 17.2495151088, 4.824e-07, 17.252958999, 4.826e-07, 17.2581877793, 4.828e-07, 17.2652229115, 4.83e-07, 17.274085659, 4.832e-07, 17.2847970894, 4.834e-07, 17.297378076, 4.836e-07, 17.3118492988, 4.838e-07, 17.3282312445, 4.84e-07, 17.3465442051, 4.842e-07, 17.3668082765, 4.844e-07, 17.389043355, 4.846e-07, 17.4132691334, 4.848e-07, 17.4395050954, 4.85e-07, 17.4677705091, 4.852e-07, 17.4980844188, 4.854e-07, 17.5304656352, 4.856e-07, 17.5649327251, 4.858e-07, 17.601503998, 4.86e-07, 17.6401974924, 4.862e-07, 17.6810309593, 4.864e-07, 17.7240218448, 4.866e-07, 17.7691872697, 4.868e-07, 17.8165440085, 4.87e-07, 17.8661084648, 4.872e-07, 17.9178966459, 4.874e-07, 17.9719241343, 4.876e-07, 18.0282060573, 4.878e-07, 18.086757054, 4.88e-07, 18.1475912399, 4.882e-07, 18.2107221691, 4.884e-07, 18.2761627939, 4.886e-07, 18.3439254212, 4.888e-07, 18.4140216667, 4.89e-07, 18.4864624062, 4.892e-07, 18.5612577239, 4.894e-07, 18.6384168575, 4.896e-07, 18.7179481407, 4.898e-07, 18.7998589424, 4.9e-07, 18.8841556031, 4.902e-07, 18.9708433678, 4.904e-07, 19.0599263158, 4.906e-07, 19.1514072878, 4.908e-07, 19.2452878092, 4.91e-07, 19.3415680105, 4.912e-07, 19.4402465448, 4.914e-07, 19.541320502, 4.916e-07, 19.6447853198, 4.918e-07, 19.7506346918, 4.92e-07, 19.8588604733, 4.922e-07, 19.9694525834, 4.924e-07, 20.082398905, 4.926e-07, 20.1976851826, 4.928e-07, 20.315294917, 4.93e-07, 20.435209259, 4.932e-07, 20.5574069004, 4.934e-07, 20.6818639636, 4.936e-07, 20.8085538906, 4.938e-07, 20.9374473305, 4.94e-07, 21.0685120266, 4.942e-07, 21.2017127036, 4.944e-07, 21.3370109549, 4.946e-07, 21.474365131, 4.948e-07, 21.6137302295, 4.95e-07, 21.7550577861, 4.952e-07, 21.8982957698, 4.954e-07, 22.0433884797, 4.956e-07, 22.1902764468, 4.958e-07, 22.3388963402, 4.96e-07, 22.4891808789, 4.962e-07, 22.6410587493, 4.964e-07, 22.7944545308, 4.966e-07, 22.9492886288, 4.968e-07, 23.1054772166, 4.97e-07, 23.2629321873, 4.972e-07, 23.4215611166, 4.974e-07, 23.5812672374, 4.976e-07, 23.7419494267, 4.978e-07, 23.903502207, 4.98e-07, 24.0658157614, 4.982e-07, 24.2287759653, 4.984e-07, 24.3922644339, 4.986e-07, 24.5561585875, 4.988e-07, 24.7203317349, 4.99e-07, 24.8846531758, 4.992e-07, 25.0489883234, 4.994e-07, 25.2131988465, 4.996e-07, 25.3771428333, 4.998e-07, 25.5406749762, 5e-07, 25.7036467783, 5.002e-07, 25.8659067819, 5.004e-07, 26.0273008184, 5.006e-07, 26.1876722808, 5.008e-07, 26.346862417, 5.01e-07, 26.5047106448, 5.012e-07, 26.6610548867, 5.014e-07, 26.8157319254, 5.016e-07, 26.968577777, 5.018e-07, 27.1194280828, 5.02e-07, 27.2681185166, 5.022e-07, 27.4144852069, 5.024e-07, 27.5583651727, 5.026e-07, 27.6995967695, 5.028e-07, 27.8380201449, 5.03e-07, 27.9734777012, 5.032e-07, 28.105814562, 5.034e-07, 28.2348790412, 5.036e-07, 28.3605231113, 5.038e-07, 28.4826028684, 5.04e-07, 28.6009789913, 5.042e-07, 28.715517192, 5.044e-07, 28.826088654, 5.046e-07, 28.9325704573, 5.048e-07, 29.0348459855, 5.05e-07, 29.1328053137, 5.052e-07, 29.2263455735, 5.054e-07, 29.3153712943, 5.056e-07, 29.3997947164, 5.058e-07, 29.4795360763, 5.06e-07, 29.5545238594, 5.062e-07, 29.6246950217, 5.064e-07, 29.689995176, 5.066e-07, 29.7503787434, 5.068e-07, 29.8058090683, 5.07e-07, 29.8562584968, 5.072e-07, 29.9017084173, 5.074e-07, 29.9421492643, 5.076e-07, 29.9775804844, 5.078e-07, 30.0080104665, 5.08e-07, 30.0334564353, 5.082e-07, 30.0539443105, 5.084e-07, 30.069508532, 5.086e-07, 30.0801918534, 5.088e-07, 30.0860451053, 5.09e-07, 30.0871269291, 5.092e-07, 30.083503486, 5.094e-07, 30.0752481406, 5.096e-07, 30.0624411233, 5.098e-07, 30.0451691734, 5.1e-07, 30.0235251649, 5.102e-07, 29.9976077182, 5.104e-07, 29.9675208004, 5.106e-07, 29.9333733156, 5.108e-07, 29.8952786892, 5.11e-07, 29.8533544471, 5.112e-07, 29.8077217944, 5.114e-07, 29.7585051925, 5.116e-07, 29.7058319408, 5.118e-07, 29.6498317617, 5.12e-07, 29.5906363924, 5.122e-07, 29.5283791856, 5.124e-07, 29.4631947194, 5.126e-07, 29.3952184192, 5.128e-07, 29.324586192, 5.13e-07, 29.2514340751, 5.132e-07, 29.1758978987, 5.134e-07, 29.0981129655, 5.136e-07, 29.0182137461, 5.138e-07, 28.9363335908, 5.14e-07, 28.8526044601, 5.142e-07, 28.7671566716, 5.144e-07, 28.6801186651, 5.146e-07, 28.5916167856, 5.148e-07, 28.5017750841, 5.15e-07, 28.4107151346, 5.152e-07, 28.3185558705, 5.154e-07, 28.2254134353, 5.156e-07, 28.1314010518, 5.158e-07, 28.0366289055, 5.16e-07, 27.9412040444, 5.162e-07, 27.8452302927, 5.164e-07, 27.7488081792, 5.166e-07, 27.6520348781, 5.168e-07, 27.5550041637, 5.17e-07, 27.4578063757, 5.172e-07, 27.3605283968, 5.174e-07, 27.2632536402, 5.176e-07, 27.166062047, 5.178e-07, 27.069030093, 5.18e-07, 26.9722308029, 5.182e-07, 26.8757337738, 5.184e-07, 26.7796052038, 5.186e-07, 26.6839079287, 5.188e-07, 26.588701463, 5.19e-07, 26.4940420476, 5.192e-07, 26.3999827002, 5.194e-07, 26.3065732717, 5.196e-07, 26.2138605044, 5.198e-07, 26.1218880948, 5.2e-07, 26.0306967574, 5.202e-07, 25.9403242923, 5.204e-07, 25.8508056533, 5.206e-07, 25.7621730179, 5.208e-07, 25.6744558584, 5.21e-07, 25.587681014, 5.212e-07, 25.5018727624, 5.214e-07, 25.417052893, 5.216e-07, 25.3332407789, 5.218e-07, 25.2504534493, 5.22e-07, 25.1687056614, 5.222e-07, 25.0880099713, 5.224e-07, 25.0083768051, 5.226e-07, 24.929814528, 5.228e-07, 24.8523295134, 5.23e-07, 24.7759262103, 5.232e-07, 24.7006072101, 5.234e-07, 24.6263733117, 5.236e-07, 24.5532235858, 5.238e-07, 24.4811554379, 5.24e-07, 24.4101646698, 5.242e-07, 24.3402455396, 5.244e-07, 24.2713908215, 5.246e-07, 24.2035918631, 5.248e-07, 24.1368386417, 5.25e-07, 24.0711198203, 5.252e-07, 24.0064228011, 5.254e-07, 23.9427337788, 5.256e-07, 23.8800377922, 5.258e-07, 23.8183187752, 5.26e-07, 23.7575596065, 5.262e-07, 23.6977421582, 5.264e-07, 23.6388473441, 5.266e-07, 23.5808551664, 5.268e-07, 23.5237447623, 5.27e-07, 23.4674944492, 5.272e-07, 23.4120817699, 5.274e-07, 23.357483537, 5.276e-07, 23.3036758763, 5.278e-07, 23.2506342703, 5.28e-07, 23.1983336014, 5.282e-07, 23.1467481939, 5.284e-07, 23.0958518568, 5.286e-07, 23.0456179253, 5.288e-07, 22.996019303, 5.29e-07, 22.9470285032, 5.292e-07, 22.898617691, 5.294e-07, 22.8507587241, 5.296e-07, 22.8034231949, 5.298e-07, 22.7565824716, 5.3e-07, 22.7102077397, 5.302e-07, 22.6642700438, 5.304e-07, 22.6187403291, 5.306e-07, 22.5735894831, 5.308e-07, 22.5287883772, 5.31e-07, 22.4843079092, 5.312e-07, 22.4401190447, 5.314e-07, 22.3961928595, 5.316e-07, 22.3525005817, 5.318e-07, 22.3090136338, 5.32e-07, 22.2657036751, 5.322e-07, 22.2225426438, 5.324e-07, 22.1795027992, 5.326e-07, 22.1365567639, 5.328e-07, 22.0936775654, 5.33e-07, 22.0508386785, 5.332e-07, 22.0080140663, 5.334e-07, 21.9651782215, 5.336e-07, 21.9223062074, 5.338e-07, 21.8793736983, 5.34e-07, 21.8363570193, 5.342e-07, 21.7932331855, 5.344e-07, 21.7499799409, 5.346e-07, 21.706575796, 5.348e-07, 21.6630000646, 5.35e-07, 21.6192329004, 5.352e-07, 21.5752553314, 5.354e-07, 21.5310492943, 5.356e-07, 21.4865976669, 5.358e-07, 21.4418842994, 5.36e-07, 21.3968940445, 5.362e-07, 21.3516127862, 5.364e-07, 21.3060274659, 5.366e-07, 21.2601261086, 5.368e-07, 21.2138978457, 5.37e-07, 21.1673329371, 5.372e-07, 21.120422791, 5.374e-07, 21.0731599815, 5.376e-07, 21.0255382649, 5.378e-07, 20.9775525929, 5.38e-07, 20.9291991248, 5.382e-07, 20.8804752366, 5.384e-07, 20.8313795283, 5.386e-07, 20.781911829, 5.388e-07, 20.7320731998, 5.39e-07, 20.6818659337, 5.392e-07, 20.6312935547, 5.394e-07, 20.5803608126, 5.396e-07, 20.5290736775, 5.398e-07, 20.4774393309, 5.4e-07, 20.4254661545, 5.402e-07, 20.3731637177, 5.404e-07, 20.3205427619, 5.406e-07, 20.2676151837, 5.408e-07, 20.2143940149, 5.41e-07, 20.1608934018, 5.412e-07, 20.1071285816, 5.414e-07, 20.0531158577, 5.416e-07, 19.9988725724, 5.418e-07, 19.9444170793, 5.42e-07, 19.8897687124, 5.422e-07, 19.8349477558, 5.424e-07, 19.77997541, 5.426e-07, 19.7248737588, 5.428e-07, 19.6696657338, 5.43e-07, 19.6143750789, 5.432e-07, 19.559026313, 5.434e-07, 19.5036446927, 5.436e-07, 19.4482561743, 5.438e-07, 19.3928873748, 5.44e-07, 19.3375655333, 5.442e-07, 19.2823184712, 5.444e-07, 19.2271745535, 5.446e-07, 19.1721626491, 5.448e-07, 19.1173120914, 5.45e-07, 19.0626526396, 5.452e-07, 19.0082144397, 5.454e-07, 18.9540279865, 5.456e-07, 18.9001240858, 5.458e-07, 18.8465338173, 5.46e-07, 18.7932884984, 5.462e-07, 18.7404196483, 5.464e-07, 18.687958954, 5.466e-07, 18.6359382359, 5.468e-07, 18.5843894158, 5.47e-07, 18.5333444849, 5.472e-07, 18.4828354737, 5.474e-07, 18.432894423, 5.476e-07, 18.3835533552, 5.478e-07, 18.3348442488, 5.48e-07, 18.2867990119, 5.482e-07, 18.2394494593, 5.484e-07, 18.1928272889, 5.486e-07, 18.1469640613, 5.488e-07, 18.1018911794, 5.49e-07, 18.0576398699, 5.492e-07, 18.0142411666, 5.494e-07, 17.9717258945, 5.496e-07, 17.9301246551, 5.498e-07, 17.8894678137, 5.5e-07, 17.8497854879, 5.502e-07, 17.8111075365, 5.504e-07, 17.7734635511, 5.506e-07, 17.7368828475, 5.508e-07, 17.7013944595, 5.51e-07, 17.667027133, 5.512e-07, 17.6338093217, 5.514e-07, 17.6017691834, 5.516e-07, 17.5709345779, 5.518e-07, 17.5413330653, 5.52e-07, 17.5129919058, 5.522e-07, 17.4859380596, 5.524e-07, 17.4601981882, 5.526e-07, 17.4357986562, 5.528e-07, 17.412765534, 5.53e-07, 17.3911246008, 5.532e-07, 17.3709013483, 5.534e-07, 17.3521209848, 5.536e-07, 17.3348084401, 5.538e-07, 17.3189883704, 5.54e-07, 17.3046851636, 5.542e-07, 17.2919229449, 5.544e-07, 17.2807255824, 5.546e-07, 17.2711166933, 5.548e-07, 17.2631196496, 5.55e-07, 17.256757584, 5.552e-07, 17.2520533956, 5.554e-07, 17.249029756, 5.556e-07, 17.2477091144, 5.558e-07, 17.2481137031, 5.56e-07, 17.250265542, 5.562e-07, 17.2541864434, 5.564e-07, 17.2598980156, 5.566e-07, 17.2674216669, 5.568e-07, 17.276778608, 5.57e-07, 17.2879898541, 5.572e-07, 17.3010762268, 5.574e-07, 17.316058354, 5.576e-07, 17.3329566703, 5.578e-07, 17.3517914154, 5.58e-07, 17.372582632, 5.582e-07, 17.3953501621, 5.584e-07, 17.4201136431, 5.586e-07, 17.4468925014, 5.588e-07, 17.4757059459, 5.59e-07, 17.5065729592, 5.592e-07, 17.5395122878, 5.594e-07, 17.5745424305, 5.596e-07, 17.6116816258, 5.598e-07, 17.6509478364, 5.6e-07, 17.6923587335, 5.602e-07, 17.7359316778, 5.604e-07, 17.7816836994, 5.606e-07, 17.8296314756, 5.608e-07, 17.8797913064, 5.61e-07, 17.9321790878, 5.612e-07, 17.9868102833, 5.614e-07, 18.0436998923, 5.616e-07, 18.1028624171, 5.618e-07, 18.1643118263, 5.62e-07, 18.2280615165, 5.622e-07, 18.2941242711, 5.624e-07, 18.3625122161, 5.626e-07, 18.4332367736, 5.628e-07, 18.5063086121, 5.63e-07, 18.5817375939, 5.632e-07, 18.6595327198, 5.634e-07, 18.7397020707, 5.636e-07, 18.822252746, 5.638e-07, 18.9071907986, 5.64e-07, 18.9945211676, 5.642e-07, 19.0842476073, 5.644e-07, 19.1763726128, 5.646e-07, 19.270897343, 5.648e-07, 19.3678215402, 5.65e-07, 19.4671434464, 5.652e-07, 19.5688597167, 5.654e-07, 19.6729653299, 5.656e-07, 19.7794534955, 5.658e-07, 19.8883155587, 5.66e-07, 19.9995409019, 5.662e-07, 20.1131168443, 5.664e-07, 20.2290285383, 5.666e-07, 20.3472588646, 5.668e-07, 20.4677883246, 5.67e-07, 20.5905949312, 5.672e-07, 20.7156540984, 5.674e-07, 20.8429385294, 5.676e-07, 20.9724181045, 5.678e-07, 21.1040597676, 5.68e-07, 21.237827414, 5.682e-07, 21.3736817775, 5.684e-07, 21.5115803193, 5.686e-07, 21.6514771181, 5.688e-07, 21.7933227628, 5.69e-07, 21.9370642467, 5.692e-07, 22.0826448672, 5.694e-07, 22.2300041275, 5.696e-07, 22.3790776449, 5.698e-07, 22.5297970635, 5.7e-07, 22.6820899744, 5.702e-07, 22.8358798428, 5.704e-07, 22.9910859432, 5.706e-07, 23.1476233042, 5.708e-07, 23.3054026634, 5.71e-07, 23.4643304325, 5.712e-07, 23.6243086758, 5.714e-07, 23.7852351009, 5.716e-07, 23.9470030632, 5.718e-07, 24.1095015856, 5.72e-07, 24.2726153947, 5.722e-07, 24.4362249723, 5.724e-07, 24.6002066262, 5.726e-07, 24.7644325781, 5.728e-07, 24.9287710716, 5.73e-07, 25.0930864998, 5.732e-07, 25.2572395534, 5.734e-07, 25.4210873902, 5.736e-07, 25.5844838251, 5.738e-07, 25.7472795432, 5.74e-07, 25.9093223335, 5.742e-07, 26.0704573453, 5.744e-07, 26.2305273661, 5.746e-07, 26.3893731207, 5.748e-07, 26.5468335918, 5.75e-07, 26.7027463603, 5.752e-07, 26.8569479655, 5.754e-07, 27.009274284, 5.756e-07, 27.1595609251, 5.758e-07, 27.3076436424, 5.76e-07, 27.4533587605, 5.762e-07, 27.5965436128, 5.764e-07, 27.7370369908, 5.766e-07, 27.8746796017, 5.768e-07, 28.0093145323, 5.77e-07, 28.1407877166, 5.772e-07, 28.2689484048, 5.774e-07, 28.3936496306, 5.776e-07, 28.5147486757, 5.778e-07, 28.6321075262, 5.78e-07, 28.7455933202, 5.782e-07, 28.8550787831, 5.784e-07, 28.9604426478, 5.786e-07, 29.0615700569, 5.788e-07, 29.1583529448, 5.79e-07, 29.2506903967, 5.792e-07, 29.3384889821, 5.794e-07, 29.4216630612, 5.796e-07, 29.5001350612, 5.798e-07, 29.5738357211, 5.8e-07, 29.6427043036, 5.802e-07, 29.7066887728, 5.804e-07, 29.7657459353, 5.806e-07, 29.8198415458, 5.808e-07, 29.8689503751, 5.81e-07, 29.9130562413, 5.812e-07, 29.9521520027, 5.814e-07, 29.9862395149, 5.816e-07, 30.0153295504, 5.818e-07, 30.0394416834, 5.82e-07, 30.058604139, 5.822e-07, 30.0728536107, 5.824e-07, 30.0822350445, 5.826e-07, 30.086801395, 5.828e-07, 30.0866133518, 5.83e-07, 30.0817390418, 5.832e-07, 30.0722537066, 5.834e-07, 30.0582393597, 5.836e-07, 30.0397844245, 5.838e-07, 30.0169833561, 5.84e-07, 29.9899362501, 5.842e-07, 29.9587484392, 5.844e-07, 29.9235300822, 5.846e-07, 29.8843957467, 5.848e-07, 29.8414639878, 5.85e-07, 29.7948569259, 5.852e-07, 29.7446998254, 5.854e-07, 29.6911206764, 5.856e-07, 29.634249782, 5.858e-07, 29.574219352, 5.86e-07, 29.5111631057, 5.862e-07, 29.4452158853, 5.864e-07, 29.376513281, 5.866e-07, 29.3051912685, 5.868e-07, 29.231385862, 5.87e-07, 29.155232781, 5.872e-07, 29.076867134, 5.874e-07, 28.9964231183, 5.876e-07, 28.9140337372, 5.878e-07, 28.8298305339, 5.88e-07, 28.7439433445, 5.882e-07, 28.6565000671, 5.884e-07, 28.5676264496, 5.886e-07, 28.4774458953, 5.888e-07, 28.3860792849, 5.89e-07, 28.2936448166, 5.892e-07, 28.2002578624, 5.894e-07, 28.1060308403, 5.896e-07, 28.0110731029, 5.898e-07, 27.9154908407, 5.9e-07, 27.8193869998, 5.902e-07, 27.7228612137, 5.904e-07, 27.6260097479, 5.906e-07, 27.5289254576, 5.908e-07, 27.4316977564, 5.91e-07, 27.3344125964, 5.912e-07, 27.2371524586, 5.914e-07, 27.1399963529, 5.916e-07, 27.0430198269, 5.918e-07, 26.9462949828, 5.92e-07, 26.8498905019, 5.922e-07, 26.7538716761, 5.924e-07, 26.6583004453, 5.926e-07, 26.5632354405, 5.928e-07, 26.468732032, 5.93e-07, 26.374842382, 5.932e-07, 26.2816155008, 5.934e-07, 26.189097307, 5.936e-07, 26.0973306902, 5.938e-07, 26.006355576, 5.94e-07, 25.9162089935, 5.942e-07, 25.8269251444, 5.944e-07, 25.7385354729, 5.946e-07, 25.6510687376, 5.948e-07, 25.5645510829, 5.95e-07, 25.4790061114, 5.952e-07, 25.3944549567, 5.954e-07, 25.3109163558, 5.956e-07, 25.2284067209, 5.958e-07, 25.1469402113, 5.96e-07, 25.0665288045, 5.962e-07, 24.9871823667, 5.964e-07, 24.9089087215, 5.966e-07, 24.8317137193, 5.968e-07, 24.7556013039, 5.97e-07, 24.6805735792, 5.972e-07, 24.6066308738, 5.974e-07, 24.5337718055, 5.976e-07, 24.4619933431, 5.978e-07, 24.3912908682, 5.98e-07, 24.321658235, 5.982e-07, 24.2530878289, 5.984e-07, 24.1855706242, 5.986e-07, 24.1190962401, 5.988e-07, 24.0536529958, 5.99e-07, 23.9892279643, 5.992e-07, 23.9258070249, 5.994e-07, 23.8633749149, 5.996e-07, 23.80191528, 5.998e-07, 23.7414107241, 6e-07, 23.6818428573, 6.002e-07, 23.6231923442, 6.004e-07, 23.5654389501, 6.006e-07, 23.5085615878, 6.008e-07, 23.4525383625, 6.01e-07, 23.3973466165, 6.012e-07, 23.3429629737, 6.014e-07, 23.2893633831, 6.016e-07, 23.236523162, 6.018e-07, 23.1844170386, 6.02e-07, 23.1330191949, 6.022e-07, 23.0823033086, 6.024e-07, 23.0322425948, 6.026e-07, 22.9828098484, 6.028e-07, 22.9339774851, 6.03e-07, 22.8857175834, 6.032e-07, 22.8380019257, 6.034e-07, 22.7908020402, 6.036e-07, 22.7440892418, 6.038e-07, 22.6978346744, 6.04e-07, 22.6520093516, 6.042e-07, 22.6065841991, 6.044e-07, 22.5615300958, 6.046e-07, 22.5168179163, 6.048e-07, 22.4724185724, 6.05e-07, 22.4283030551, 6.052e-07, 22.384442477, 6.054e-07, 22.3408081142, 6.056e-07, 22.2973714486, 6.058e-07, 22.2541042103, 6.06e-07, 22.2109784194, 6.062e-07, 22.1679664288, 6.064e-07, 22.1250409655, 6.066e-07, 22.0821751731, 6.068e-07, 22.0393426534, 6.07e-07, 21.9965175075, 6.072e-07, 21.9536743773, 6.074e-07, 21.9107884864, 6.076e-07, 21.8678356797, 6.078e-07, 21.8247924637, 6.08e-07, 21.7816360455, 6.082e-07, 21.7383443711, 6.084e-07, 21.694896163, 6.086e-07, 21.6512709571, 6.088e-07, 21.6074491382, 6.09e-07, 21.5634119752, 6.092e-07, 21.519141654, 6.094e-07, 21.4746213106, 6.096e-07, 21.4298350614, 6.098e-07, 21.3847680332, 6.1e-07, 21.3394063912, 6.102e-07, 21.2937373653, 6.104e-07, 21.2477492753, 6.106e-07, 21.2014315534, 6.108e-07, 21.154774766, 6.11e-07, 21.1077706324, 6.112e-07, 21.0604120428, 6.114e-07, 21.012693073, 6.116e-07, 20.9646089979, 6.118e-07, 20.9161563024, 6.12e-07, 20.8673326906, 6.122e-07, 20.8181370919, 6.124e-07, 20.7685696662, 6.126e-07, 20.718631805, 6.128e-07, 20.6683261323, 6.13e-07, 20.6176565014, 6.132e-07, 20.5666279906, 6.134e-07, 20.5152468961, 6.136e-07, 20.4635207226, 6.138e-07, 20.4114581721, 6.14e-07, 20.3590691302, 6.142e-07, 20.3063646502, 6.144e-07, 20.2533569352, 6.146e-07, 20.2000593186, 6.148e-07, 20.1464862418, 6.15e-07, 20.0926532308, 6.152e-07, 20.0385768704, 6.154e-07, 19.9842747774, 6.156e-07, 19.9297655715, 6.158e-07, 19.8750688449, 6.16e-07, 19.8202051309, 6.162e-07, 19.7651958706, 6.164e-07, 19.7100633788, 6.166e-07, 19.6548308087, 6.168e-07, 19.5995221158, 6.17e-07, 19.544162021, 6.172e-07, 19.4887759722, 6.174e-07, 19.4333901071, 6.176e-07, 19.3780312133, 6.178e-07, 19.3227266903, 6.18e-07, 19.2675045092, 6.182e-07, 19.2123931741, 6.184e-07, 19.1574216825, 6.186e-07, 19.1026194858, 6.188e-07, 19.0480164509, 6.19e-07, 18.9936428212, 6.192e-07, 18.9395291786, 6.194e-07, 18.885706406, 6.196e-07, 18.8322056506, 6.198e-07, 18.7790582872, 6.2e-07, 18.7262958837, 6.202e-07, 18.6739501658, 6.204e-07, 18.6220529846, 6.206e-07, 18.5706362834, 6.208e-07, 18.519732067, 6.21e-07, 18.4693723714, 6.212e-07, 18.4195892351, 6.214e-07, 18.3704146715, 6.216e-07, 18.3218806423, 6.218e-07, 18.2740190331, 6.22e-07, 18.2268616294, 6.222e-07, 18.1804400944, 6.224e-07, 18.134785948, 6.226e-07, 18.0899305477, 6.228e-07, 18.0459050702, 6.23e-07, 18.0027404945, 6.232e-07, 17.960467587, 6.234e-07, 17.9191168871, 6.236e-07, 17.8787186948, 6.238e-07, 17.8393030589, 6.24e-07, 17.8008997675, 6.242e-07, 17.7635383389, 6.244e-07, 17.7272480139, 6.246e-07, 17.6920577493, 6.248e-07, 17.6579962131, 6.25e-07, 17.6250917799, 6.252e-07, 17.5933725275, 6.254e-07, 17.5628662356, 6.256e-07, 17.5336003838, 6.258e-07, 17.5056021515, 6.26e-07, 17.4788984186, 6.262e-07, 17.4535157669, 6.264e-07, 17.4294804816, 6.266e-07, 17.4068185546, 6.268e-07, 17.3855556876, 6.27e-07, 17.3657172957, 6.272e-07, 17.3473285121, 6.274e-07, 17.3304141925, 6.276e-07, 17.3149989207, 6.278e-07, 17.3011070134, 6.28e-07, 17.2887625263, 6.282e-07, 17.2779892595, 6.284e-07, 17.2688107639, 6.286e-07, 17.2612503465, 6.288e-07, 17.2553310768, 6.29e-07, 17.2510757924, 6.292e-07, 17.2485071047, 6.294e-07, 17.2476474039, 6.296e-07, 17.2485188651, 6.298e-07, 17.2511434518, 6.3e-07, 17.2555429214, 6.302e-07, 17.2617388281, 6.304e-07, 17.269752527, 6.306e-07, 17.2796051759, 6.308e-07, 17.2913177382, 6.31e-07, 17.3049109833, 6.312e-07, 17.3204054874, 6.314e-07, 17.3378216328, 6.316e-07, 17.3571796067, 6.318e-07, 17.3784993983, 6.32e-07, 17.4018007951, 6.322e-07, 17.4271033785, 6.324e-07, 17.4544265173, 6.326e-07, 17.4837893605, 6.328e-07, 17.5152108284, 6.33e-07, 17.5487096021, 6.332e-07, 17.584304112, 6.334e-07, 17.6220125241, 6.336e-07, 17.6618527244, 6.338e-07, 17.7038423028, 6.34e-07, 17.7479985332, 6.342e-07, 17.7943383533, 6.344e-07, 17.8428783417, 6.346e-07, 17.8936346925, 6.348e-07, 17.9466231886, 6.35e-07, 18.0018591721, 6.352e-07, 18.0593575124, 6.354e-07, 18.1191325721, 6.356e-07, 18.1811981702, 6.358e-07, 18.2455675428, 6.36e-07, 18.3122533013, 6.362e-07, 18.3812673874, 6.364e-07, 18.4526210259, 6.366e-07, 18.5263246742, 6.368e-07, 18.602387969, 6.37e-07, 18.6808196699, 6.372e-07, 18.7616276006, 6.374e-07, 18.8448185859, 6.376e-07, 18.9303983866, 6.378e-07, 19.018371631, 6.38e-07, 19.1087417425, 6.382e-07, 19.2015108655, 6.384e-07, 19.2966797865, 6.386e-07, 19.3942478534, 6.388e-07, 19.4942128909, 6.39e-07, 19.596571113, 6.392e-07, 19.7013170328, 6.394e-07, 19.8084433688, 6.396e-07, 19.9179409492, 6.398e-07, 20.0297986124, 6.4e-07, 20.1440031062, 6.402e-07, 20.2605389838, 6.404e-07, 20.3793884976, 6.406e-07, 20.5005314918, 6.408e-07, 20.6239452926, 6.41e-07, 20.7496045974, 6.412e-07, 20.8774813627, 6.414e-07, 21.0075446916, 6.416e-07, 21.1397607207, 6.418e-07, 21.2740925077, 6.42e-07, 21.4104999187, 6.422e-07, 21.5489395178, 6.424e-07, 21.6893644572, 6.426e-07, 21.8317243707, 6.428e-07, 21.9759652696, 6.43e-07, 22.1220294419, 6.432e-07, 22.2698553567, 6.434e-07, 22.4193775728, 6.436e-07, 22.5705266541, 6.438e-07, 22.7232290909, 6.44e-07, 22.8774072295, 6.442e-07, 23.0329792097, 6.444e-07, 23.1898589121, 6.446e-07, 23.347955916, 6.448e-07, 23.5071754679, 6.45e-07, 23.6674184628, 6.452e-07, 23.828581439, 6.454e-07, 23.9905565862, 6.456e-07, 24.15323177, 6.458e-07, 24.3164905715, 6.46e-07, 24.4802123447, 6.462e-07, 24.6442722908, 6.464e-07, 24.8085415523, 6.466e-07, 24.9728873259, 6.468e-07, 25.1371729954, 6.47e-07, 25.3012582856, 6.472e-07, 25.4649994373, 6.474e-07, 25.6282494036, 6.476e-07, 25.7908580682, 6.478e-07, 25.9526724854, 6.48e-07, 26.1135371425, 6.482e-07, 26.2732942428, 6.484e-07, 26.4317840113, 6.486e-07, 26.58884502, 6.488e-07, 26.7443145342, 6.49e-07, 26.8980288774, 6.492e-07, 27.0498238148, 6.494e-07, 27.1995349534, 6.496e-07, 27.3469981577, 6.498e-07, 27.4920499797, 6.5e-07, 27.6345280994, 6.502e-07, 27.7742717777, 6.504e-07, 27.9111223146, 6.506e-07, 28.0449235152, 6.508e-07, 28.1755221577, 6.51e-07, 28.3027684621, 6.512e-07, 28.4265165571, 6.514e-07, 28.5466249427, 6.516e-07, 28.6629569445, 6.518e-07, 28.7753811583, 6.52e-07, 28.8837718816, 6.522e-07, 28.9880095291, 6.524e-07, 29.0879810301, 6.526e-07, 29.1835802041, 6.528e-07, 29.2747081139, 6.53e-07, 29.3612733914, 6.532e-07, 29.4431925364, 6.534e-07, 29.5203901845, 6.536e-07, 29.5927993434, 6.538e-07, 29.6603615958, 6.54e-07, 29.7230272669, 6.542e-07, 29.7807555565, 6.544e-07, 29.8335146344, 6.546e-07, 29.8812816986, 6.548e-07, 29.924042996, 6.55e-07, 29.961793806, 6.552e-07, 29.9945383871, 6.554e-07, 30.0222898874, 6.556e-07, 30.0450702194, 6.558e-07, 30.0629099008, 6.56e-07, 30.0758478627, 6.562e-07, 30.0839312263, 6.564e-07, 30.0872150502, 6.566e-07, 30.0857620509, 6.568e-07, 30.0796422977, 6.57e-07, 30.0689328845, 6.572e-07, 30.0537175817, 6.574e-07, 30.0340864696, 6.576e-07, 30.0101355564, 6.578e-07, 29.9819663833, 6.58e-07, 29.9496856195, 6.582e-07, 29.9134046482, 6.584e-07, 29.8732391489, 6.586e-07, 29.8293086753, 6.588e-07, 29.7817362329, 6.59e-07, 29.7306478588, 6.592e-07, 29.6761722042, 6.594e-07, 29.6184401236, 6.596e-07, 29.5575842705, 6.598e-07, 29.4937387032, 6.6e-07, 29.4270385012, 6.602e-07, 29.3576193928, 6.604e-07, 29.2856173978, 6.606e-07, 29.2111684832, 6.608e-07, 29.1344082349, 6.61e-07, 29.0554715457, 6.612e-07, 28.9744923192, 6.614e-07, 28.8916031923, 6.616e-07, 28.8069352735, 6.618e-07, 28.7206179006, 6.62e-07, 28.6327784144, 6.622e-07, 28.5435419521, 6.624e-07, 28.4530312564, 6.626e-07, 28.361366503, 6.628e-07, 28.2686651449, 6.63e-07, 28.1750417728, 6.632e-07, 28.0806079924, 6.634e-07, 27.9854723163, 6.636e-07, 27.8897400715, 6.638e-07, 27.7935133211, 6.64e-07, 27.6968907993, 6.642e-07, 27.59996786, 6.644e-07, 27.502836437, 6.646e-07, 27.4055850161, 6.648e-07, 27.3082986184, 6.65e-07, 27.2110587927, 6.652e-07, 27.1139436182, 6.654e-07, 27.0170277157, 6.656e-07, 26.9203822664, 6.658e-07, 26.8240750384, 6.66e-07, 26.7281704198, 6.662e-07, 26.6327294579, 6.664e-07, 26.5378099035, 6.666e-07, 26.4434662603, 6.668e-07, 26.3497498388, 6.67e-07, 26.2567088135, 6.672e-07, 26.1643882834, 6.674e-07, 26.0728303361, 6.676e-07, 25.9820741128, 6.678e-07, 25.8921558771, 6.68e-07, 25.8031090832, 6.682e-07, 25.7149644477, 6.684e-07, 25.62775002, 6.686e-07, 25.5414912553, 6.688e-07, 25.4562110863, 6.69e-07, 25.3719299962, 6.692e-07, 25.2886660907, 6.694e-07, 25.2064351703, 6.696e-07, 25.1252508017, 6.698e-07, 25.0451243889, 6.7e-07, 24.9660652428, 6.702e-07, 24.8880806508, 6.704e-07, 24.8111759448, 6.706e-07, 24.7353545683, 6.708e-07, 24.6606181423, 6.71e-07, 24.5869665301, 6.712e-07, 24.5143979006, 6.714e-07, 24.4429087905, 6.716e-07, 24.3724941658, 6.718e-07, 24.3031474804, 6.72e-07, 24.2348607355, 6.722e-07, 24.1676245363, 6.724e-07, 24.1014281474, 6.726e-07, 24.0362595485, 6.728e-07, 23.9721054869, 6.73e-07, 23.9089515303, 6.732e-07, 23.8467821181, 6.734e-07, 23.7855806116, 6.736e-07, 23.7253293431, 6.738e-07, 23.6660096643, 6.74e-07, 23.6076019938, 6.742e-07, 23.5500858636, 6.744e-07, 23.4934399652, 6.746e-07, 23.4376421947, 6.748e-07, 23.3826696972, 6.75e-07, 23.3284989113, 6.752e-07, 23.275105612, 6.754e-07, 23.2224649544, 6.756e-07, 23.170551516, 6.758e-07, 23.1193393391, 6.76e-07, 23.0688019732, 6.762e-07, 23.0189125166, 6.764e-07, 22.9696436582, 6.766e-07, 22.9209677192, 6.768e-07, 22.8728566944, 6.77e-07, 22.8252822941, 6.772e-07, 22.778215985, 6.774e-07, 22.7316290321, 6.776e-07, 22.6854925402, 6.778e-07, 22.6397774952, 6.78e-07, 22.5944548061, 6.782e-07, 22.5494953468, 6.784e-07, 22.5048699974, 6.786e-07, 22.460549687, 6.788e-07, 22.4165054351, 6.79e-07, 22.3727083941, 6.792e-07, 22.329129891, 6.794e-07, 22.2857414704, 6.796e-07, 22.2425149361, 6.798e-07, 22.1994223932, 6.8e-07, 22.156436291, 6.802e-07, 22.1135294643, 6.804e-07, 22.0706751756, 6.806e-07, 22.0278471565, 6.808e-07, 21.9850196495, 6.81e-07, 21.9421674485, 6.812e-07, 21.8992659399, 6.814e-07, 21.8562911425, 6.816e-07, 21.8132197469, 6.818e-07, 21.7700291549, 6.82e-07, 21.7266975172, 6.822e-07, 21.6832037711, 6.824e-07, 21.639527677, 6.826e-07, 21.5956498536, 6.828e-07, 21.5515518127, 6.83e-07, 21.5072159922, 6.832e-07, 21.4626257881, 6.834e-07, 21.4177655853, 6.836e-07, 21.3726207867, 6.838e-07, 21.3271778406, 6.84e-07, 21.2814242674, 6.842e-07, 21.235348683, 6.844e-07, 21.1889408222, 6.846e-07, 21.1421915592, 6.848e-07, 21.0950929258, 6.85e-07, 21.0476381291, 6.852e-07, 20.9998215656, 6.854e-07, 20.9516388339, 6.856e-07, 20.9030867456, 6.858e-07, 20.854163333, 6.86e-07, 20.8048678556, 6.862e-07, 20.7552008035, 6.864e-07, 20.7051638996, 6.866e-07, 20.6547600979, 6.868e-07, 20.6039935812, 6.87e-07, 20.5528697554, 6.872e-07, 20.5013952423, 6.874e-07, 20.449577869, 6.876e-07, 20.3974266569, 6.878e-07, 20.3449518064, 6.88e-07, 20.2921646815, 6.882e-07, 20.2390777908, 6.884e-07, 20.1857047671, 6.886e-07, 20.1320603456, 6.888e-07, 20.0781603389, 6.89e-07, 20.0240216117, 6.892e-07, 19.9696620528, 6.894e-07, 19.9151005461, 6.896e-07, 19.8603569395, 6.898e-07, 19.8054520134, 6.9e-07, 19.7504074467, 6.902e-07, 19.6952457828, 6.904e-07, 19.639990394, 6.906e-07, 19.5846654448, 6.908e-07, 19.5292958549, 6.91e-07, 19.4739072613, 6.912e-07, 19.4185259799, 6.914e-07, 19.3631789665, 6.916e-07, 19.3078937778, 6.918e-07, 19.2526985318, 6.92e-07, 19.197621869, 6.922e-07, 19.1426929126, 6.924e-07, 19.0879412293, 6.926e-07, 19.0333967908, 6.928e-07, 18.9790899352, 6.93e-07, 18.9250513287, 6.932e-07, 18.871311929, 6.934e-07, 18.8179029476, 6.936e-07, 18.7648558147, 6.938e-07, 18.7122021439, 6.94e-07, 18.6599736979, 6.942e-07, 18.6082023555, 6.944e-07, 18.5569200796, 6.946e-07, 18.5061588863, 6.948e-07, 18.455950815, 6.95e-07, 18.4063279002, 6.952e-07, 18.3573221439, 6.954e-07, 18.3089654898, 6.956e-07, 18.2612897988, 6.958e-07, 18.2143268258, 6.96e-07, 18.1681081974, 6.962e-07, 18.1226653919, 6.964e-07, 18.07802972, 6.966e-07, 18.0342323067, 6.968e-07, 17.9913040757, 6.97e-07, 17.9492757335, 6.972e-07, 17.9081777566, 6.974e-07, 17.8680403785, 6.976e-07, 17.8288935791, 6.978e-07, 17.7907670748, 6.98e-07, 17.7536903101, 6.982e-07, 17.7176924502, 6.984e-07, 17.6828023749, 6.986e-07, 17.6490486736, 6.988e-07, 17.6164596417, 6.99e-07, 17.5850632771, 6.992e-07, 17.5548872789, 6.994e-07, 17.5259590462, 6.996e-07, 17.498305678, 6.998e-07, 17.471953974, 7e-07, 17.446930436, 7.002e-07, 17.4232612703, 7.004e-07, 17.4009723906, 7.006e-07, 17.3800894211, 7.008e-07, 17.3606377008, 7.01e-07, 17.3426422881, 7.012e-07, 17.3261279652, 7.014e-07, 17.3111192434, 7.016e-07, 17.297640369, 7.018e-07, 17.2857153284, 7.02e-07, 17.2753678543, 7.022e-07, 17.2666214316, 7.024e-07, 17.2594993028, 7.026e-07, 17.2540244747, 7.028e-07, 17.2502197236, 7.03e-07, 17.248107601, 7.032e-07, 17.247710439, 7.034e-07, 17.2490503552, 7.036e-07, 17.2521492576, 7.038e-07, 17.2570288486, 7.04e-07, 17.2637106286, 7.042e-07, 17.2722158995, 7.044e-07, 17.282565767, 7.046e-07, 17.294781142, 7.048e-07, 17.3088827422, 7.05e-07, 17.3248910918, 7.052e-07, 17.3428265211, 7.054e-07, 17.3627091642, 7.056e-07, 17.3845589566, 7.058e-07, 17.4083956311, 7.06e-07, 17.4342387126, 7.062e-07, 17.4621075118, 7.064e-07, 17.4920211172, 7.066e-07, 17.5239983858, 7.068e-07, 17.5580579329, 7.07e-07, 17.5942181191, 7.072e-07, 17.6324970368, 7.074e-07, 17.6729124945, 7.076e-07, 17.715481999, 7.078e-07, 17.7602227361, 7.08e-07, 17.8071515495, 7.082e-07, 17.8562849171, 7.084e-07, 17.9076389254, 7.086e-07, 17.961229242, 7.088e-07, 18.0170710852, 7.09e-07, 18.0751791919, 7.092e-07, 18.1355677824, 7.094e-07, 18.1982505234, 7.096e-07, 18.2632404874, 7.098e-07, 18.3305501105, 7.1e-07, 18.4001911468, 7.102e-07, 18.4721746203, 7.104e-07, 18.5465107731, 7.106e-07, 18.6232090124, 7.108e-07, 18.7022778524, 7.11e-07, 18.783724855, 7.112e-07, 18.8675565658, 7.114e-07, 18.9537784486, 7.116e-07, 19.0423948154, 7.118e-07, 19.1334087537, 7.12e-07, 19.2268220513, 7.122e-07, 19.3226351165, 7.124e-07, 19.4208468969, 7.126e-07, 19.5214547934, 7.128e-07, 19.6244545724, 7.13e-07, 19.7298402747, 7.132e-07, 19.8376041209, 7.134e-07, 19.9477364147, 7.136e-07, 20.0602254435, 7.138e-07, 20.1750573763, 7.14e-07, 20.2922161591, 7.142e-07, 20.4116834086, 7.144e-07, 20.5334383038, 7.146e-07, 20.6574574763, 7.148e-07, 20.7837148986, 7.15e-07, 20.9121817724, 7.152e-07, 21.0428264156, 7.154e-07, 21.1756141493, 7.156e-07, 21.3105071855, 7.158e-07, 21.4474645148, 7.16e-07, 21.5864417959, 7.162e-07, 21.7273912471, 7.164e-07, 21.8702615399, 7.166e-07, 22.0149976956, 7.168e-07, 22.1615409864, 7.17e-07, 22.3098288405, 7.172e-07, 22.4597947524, 7.174e-07, 22.6113681998, 7.176e-07, 22.7644745673, 7.178e-07, 22.9190350777, 7.18e-07, 23.0749667323, 7.182e-07, 23.2321822607, 7.184e-07, 23.3905900817, 7.186e-07, 23.5500942751, 7.188e-07, 23.7105945663, 7.19e-07, 23.8719863247, 7.192e-07, 24.0341605764, 7.194e-07, 24.1970040323, 7.196e-07, 24.3603991324, 7.198e-07, 24.5242241078, 7.2e-07, 24.6883530602, 7.202e-07, 24.8526560611, 7.204e-07, 25.0169992696, 7.206e-07, 25.1812450715, 7.208e-07, 25.3452522381, 7.21e-07, 25.5088761077, 7.212e-07, 25.6719687869, 7.214e-07, 25.8343793755, 7.216e-07, 25.9959542121, 7.218e-07, 26.1565371421, 7.22e-07, 26.315969807, 7.222e-07, 26.4740919552, 7.224e-07, 26.6307417732, 7.226e-07, 26.7857562368, 7.228e-07, 26.9389714812, 7.23e-07, 27.0902231893, 7.232e-07, 27.2393469957, 7.234e-07, 27.3861789069, 7.236e-07, 27.5305557336, 7.238e-07, 27.6723155358, 7.24e-07, 27.8112980761, 7.242e-07, 27.9473452813, 7.244e-07, 28.0803017084, 7.246e-07, 28.2100150136, 7.248e-07, 28.3363364203, 7.25e-07, 28.4591211858, 7.252e-07, 28.5782290609, 7.254e-07, 28.6935247428, 7.256e-07, 28.8048783162, 7.258e-07, 28.9121656806, 7.26e-07, 29.0152689611, 7.262e-07, 29.1140769008, 7.264e-07, 29.20848523, 7.266e-07, 29.2983970122, 7.268e-07, 29.3837229634, 7.27e-07, 29.4643817423, 7.272e-07, 29.54030021, 7.274e-07, 29.6114136577, 7.276e-07, 29.6776659998, 7.278e-07, 29.7390099322, 7.28e-07, 29.7954070549, 7.282e-07, 29.846827957, 7.284e-07, 29.8932522651, 7.286e-07, 29.9346686539, 7.288e-07, 29.9710748199, 7.29e-07, 30.0024774181, 7.292e-07, 30.028891963, 7.294e-07, 30.0503426942, 7.296e-07, 30.0668624079, 7.298e-07, 30.0784922569, 7.3e-07, 30.0852815191, 7.302e-07, 30.0872873374, 7.304e-07, 30.084574433, 7.306e-07, 30.0772147937, 7.308e-07, 30.065287341, 7.31e-07, 30.0488775754, 7.312e-07, 30.0280772068, 7.314e-07, 30.0029837679, 7.316e-07, 29.9737002165, 7.318e-07, 29.9403345281, 7.32e-07, 29.9029992805, 7.322e-07, 29.8618112347, 7.324e-07, 29.8168909122, 7.326e-07, 29.7683621736, 7.328e-07, 29.7163517986, 7.33e-07, 29.6609890698, 7.332e-07, 29.6024053638, 7.334e-07, 29.5407337499, 7.336e-07, 29.4761085974, 7.338e-07, 29.4086651959, 7.34e-07, 29.3385393867, 7.342e-07, 29.2658672086, 7.344e-07, 29.1907845577, 7.346e-07, 29.1134268639, 7.348e-07, 29.0339287828, 7.35e-07, 28.9524239046, 7.352e-07, 28.8690444808, 7.354e-07, 28.7839211676, 7.356e-07, 28.6971827882, 7.358e-07, 28.6089561116, 7.36e-07, 28.51936565, 7.362e-07, 28.4285334734, 7.364e-07, 28.3365790412, 7.366e-07, 28.2436190511, 7.368e-07, 28.1497673039, 7.37e-07, 28.055134585, 7.372e-07, 27.9598285603, 7.374e-07, 27.8639536877)'
Lbulk nb ns L = 'pwl(time, 0, 2.65835566877e-07, 2e-10, 2.64637186341e-07, 4e-10, 2.63441580082e-07, 6e-10, 2.62249659177e-07, 8e-10, 2.61062296121e-07, 1e-09, 2.59880324953e-07, 1.2e-09, 2.58704541477e-07, 1.4e-09, 2.57535703567e-07, 1.6e-09, 2.56374531559e-07, 1.8e-09, 2.55221708705e-07, 2e-09, 2.54077881705e-07, 2.2e-09, 2.52943661285e-07, 2.4e-09, 2.51819622835e-07, 2.6e-09, 2.5070630709e-07, 2.8e-09, 2.49604220846e-07, 3e-09, 2.48513837712e-07, 3.2e-09, 2.47435598897e-07, 3.4e-09, 2.46369914004e-07, 3.6e-09, 2.45317161858e-07, 3.8e-09, 2.44277691336e-07, 4e-09, 2.43251822216e-07, 4.2e-09, 2.42239846025e-07, 4.4e-09, 2.41242026891e-07, 4.6e-09, 2.40258602397e-07, 4.8e-09, 2.39289784432e-07, 5e-09, 2.38335760027e-07, 5.2e-09, 2.37396692198e-07, 5.4e-09, 2.36472720765e-07, 5.6e-09, 2.35563963165e-07, 5.8e-09, 2.34670515255e-07, 6e-09, 2.33792452089e-07, 6.2e-09, 2.32929828693e-07, 6.4e-09, 2.32082680812e-07, 6.6e-09, 2.31251025646e-07, 6.8e-09, 2.3043486256e-07, 7e-09, 2.29634173789e-07, 7.2e-09, 2.2884892511e-07, 7.4e-09, 2.28079066501e-07, 7.6e-09, 2.27324532781e-07, 7.8e-09, 2.26585244234e-07, 8e-09, 2.25861107207e-07, 8.2e-09, 2.25152014691e-07, 8.4e-09, 2.24457846894e-07, 8.6e-09, 2.23778471781e-07, 8.8e-09, 2.23113745608e-07, 9e-09, 2.22463513431e-07, 9.2e-09, 2.21827609611e-07, 9.4e-09, 2.21205858287e-07, 9.6e-09, 2.2059807385e-07, 9.8e-09, 2.2000406139e-07, 1e-08, 2.19423617142e-07, 1.02e-08, 2.18856528908e-07, 1.04e-08, 2.18302576475e-07, 1.06e-08, 2.1776153202e-07, 1.08e-08, 2.172331605e-07, 1.1e-08, 2.16717220043e-07, 1.12e-08, 2.1621346232e-07, 1.14e-08, 2.15721632914e-07, 1.16e-08, 2.15241471682e-07, 1.18e-08, 2.14772713111e-07, 1.2e-08, 2.14315086668e-07, 1.22e-08, 2.1386831714e-07, 1.24e-08, 2.13432124981e-07, 1.26e-08, 2.13006226646e-07, 1.28e-08, 2.12590334926e-07, 1.3e-08, 2.12184159281e-07, 1.32e-08, 2.1178740617e-07, 1.34e-08, 2.1139977938e-07, 1.36e-08, 2.11020980357e-07, 1.38e-08, 2.10650708533e-07, 1.4e-08, 2.1028866166e-07, 1.42e-08, 2.09934536132e-07, 1.44e-08, 2.09588027324e-07, 1.46e-08, 2.09248829922e-07, 1.48e-08, 2.08916638254e-07, 1.5e-08, 2.0859114663e-07, 1.52e-08, 2.08272049678e-07, 1.54e-08, 2.07959042684e-07, 1.56e-08, 2.07651821932e-07, 1.58e-08, 2.0735008505e-07, 1.6e-08, 2.07053531352e-07, 1.62e-08, 2.06761862191e-07, 1.64e-08, 2.06474781298e-07, 1.66e-08, 2.06191995142e-07, 1.68e-08, 2.05913213272e-07, 1.7e-08, 2.05638148675e-07, 1.72e-08, 2.05366518123e-07, 1.74e-08, 2.05098042525e-07, 1.76e-08, 2.04832447279e-07, 1.78e-08, 2.04569462618e-07, 1.8e-08, 2.0430882396e-07, 1.82e-08, 2.04050272252e-07, 1.84e-08, 2.03793554307e-07, 1.86e-08, 2.03538423148e-07, 1.88e-08, 2.03284638335e-07, 1.9e-08, 2.03031966295e-07, 1.92e-08, 2.02780180641e-07, 1.94e-08, 2.02529062488e-07, 1.96e-08, 2.0227840076e-07, 1.98e-08, 2.02027992482e-07, 2e-08, 2.01777643074e-07, 2.02e-08, 2.01527166625e-07, 2.04e-08, 2.01276386163e-07, 2.06e-08, 2.01025133906e-07, 2.08e-08, 2.00773251506e-07, 2.1e-08, 2.00520590279e-07, 2.12e-08, 2.00267011417e-07, 2.14e-08, 2.00012386189e-07, 2.16e-08, 1.99756596124e-07, 2.18e-08, 1.99499533181e-07, 2.2e-08, 1.99241099897e-07, 2.22e-08, 1.98981209525e-07, 2.24e-08, 1.98719786148e-07, 2.26e-08, 1.98456764774e-07, 2.28e-08, 1.98192091421e-07, 2.3e-08, 1.97925723175e-07, 2.32e-08, 1.97657628231e-07, 2.34e-08, 1.97387785917e-07, 2.36e-08, 1.97116186696e-07, 2.38e-08, 1.96842832152e-07, 2.4e-08, 1.9656773495e-07, 2.42e-08, 1.96290918786e-07, 2.44e-08, 1.96012418314e-07, 2.46e-08, 1.9573227905e-07, 2.48e-08, 1.95450557264e-07, 2.5e-08, 1.95167319852e-07, 2.52e-08, 1.94882644191e-07, 2.54e-08, 1.94596617974e-07, 2.56e-08, 1.94309339034e-07, 2.58e-08, 1.94020915146e-07, 2.6e-08, 1.93731463824e-07, 2.62e-08, 1.93441112089e-07, 2.64e-08, 1.9314999624e-07, 2.66e-08, 1.92858261599e-07, 2.68e-08, 1.92566062254e-07, 2.7e-08, 1.92273560784e-07, 2.72e-08, 1.91980927982e-07, 2.74e-08, 1.91688342558e-07, 2.76e-08, 1.91395990849e-07, 2.78e-08, 1.91104066509e-07, 2.8e-08, 1.90812770198e-07, 2.82e-08, 1.9052230927e-07, 2.84e-08, 1.90232897452e-07, 2.86e-08, 1.89944754522e-07, 2.88e-08, 1.89658105982e-07, 2.9e-08, 1.89373182741e-07, 2.92e-08, 1.89090220781e-07, 2.94e-08, 1.88809460839e-07, 2.96e-08, 1.88531148084e-07, 2.98e-08, 1.88255531798e-07, 3e-08, 1.87982865056e-07, 3.02e-08, 1.87713404422e-07, 3.04e-08, 1.87447409635e-07, 3.06e-08, 1.87185143313e-07, 3.08e-08, 1.86926870658e-07, 3.1e-08, 1.86672859166e-07, 3.12e-08, 1.8642337835e-07, 3.14e-08, 1.86178699465e-07, 3.16e-08, 1.85939095247e-07, 3.18e-08, 1.85704839657e-07, 3.2e-08, 1.85476207637e-07, 3.22e-08, 1.8525347487e-07, 3.24e-08, 1.85036917558e-07, 3.26e-08, 1.84826812206e-07, 3.28e-08, 1.8462343541e-07, 3.3e-08, 1.84427063667e-07, 3.32e-08, 1.84237973188e-07, 3.34e-08, 1.84056439718e-07, 3.36e-08, 1.83882738377e-07, 3.38e-08, 1.83717143502e-07, 3.4e-08, 1.835599285e-07, 3.42e-08, 1.83411365716e-07, 3.44e-08, 1.83271726306e-07, 3.46e-08, 1.83141280122e-07, 3.48e-08, 1.83020295603e-07, 3.5e-08, 1.8290903968e-07, 3.52e-08, 1.82807777684e-07, 3.54e-08, 1.82716773266e-07, 3.56e-08, 1.82636288328e-07, 3.58e-08, 1.82566582949e-07, 3.6e-08, 1.82507915334e-07, 3.62e-08, 1.82460541758e-07, 3.64e-08, 1.82424716524e-07, 3.66e-08, 1.82400691917e-07, 3.68e-08, 1.82388718177e-07, 3.7e-08, 1.82389043461e-07, 3.72e-08, 1.82401913824e-07, 3.74e-08, 1.82427573192e-07, 3.76e-08, 1.82466263345e-07, 3.78e-08, 1.825182239e-07, 3.8e-08, 1.82583692298e-07, 3.82e-08, 1.82662903786e-07, 3.84e-08, 1.82756091409e-07, 3.86e-08, 1.82863485997e-07, 3.88e-08, 1.82985316152e-07, 3.9e-08, 1.83121808233e-07, 3.92e-08, 1.83273186344e-07, 3.94e-08, 1.83439672313e-07, 3.96e-08, 1.83621485675e-07, 3.98e-08, 1.83818843646e-07, 4e-08, 1.84031961097e-07, 4.02e-08, 1.84261050518e-07, 4.04e-08, 1.84506321987e-07, 4.06e-08, 1.84767983117e-07, 4.08e-08, 1.85046239013e-07, 4.1e-08, 1.85341292208e-07, 4.12e-08, 1.85653342601e-07, 4.14e-08, 1.85982587381e-07, 4.16e-08, 1.8632922094e-07, 4.18e-08, 1.86693434782e-07, 4.2e-08, 1.87075417415e-07, 4.22e-08, 1.87475354237e-07, 4.24e-08, 1.87893427402e-07, 4.26e-08, 1.88329815683e-07, 4.28e-08, 1.88784694314e-07, 4.3e-08, 1.89258234819e-07, 4.32e-08, 1.89750604827e-07, 4.34e-08, 1.90261967873e-07, 4.36e-08, 1.90792483176e-07, 4.38e-08, 1.91342305407e-07, 4.4e-08, 1.91911584434e-07, 4.42e-08, 1.9250046505e-07, 4.44e-08, 1.93109086683e-07, 4.46e-08, 1.9373758308e-07, 4.48e-08, 1.94386081979e-07, 4.5e-08, 1.95054704749e-07, 4.52e-08, 1.95743566017e-07, 4.54e-08, 1.96452773266e-07, 4.56e-08, 1.97182426411e-07, 4.58e-08, 1.9793261735e-07, 4.6e-08, 1.98703429494e-07, 4.62e-08, 1.99494937264e-07, 4.64e-08, 2.00307205571e-07, 4.66e-08, 2.0114028926e-07, 4.68e-08, 2.01994232537e-07, 4.7e-08, 2.02869068361e-07, 4.72e-08, 2.03764817814e-07, 4.74e-08, 2.04681489439e-07, 4.76e-08, 2.05619078555e-07, 4.78e-08, 2.06577566541e-07, 4.8e-08, 2.07556920092e-07, 4.82e-08, 2.08557090454e-07, 4.84e-08, 2.09578012622e-07, 4.86e-08, 2.10619604523e-07, 4.88e-08, 2.11681766164e-07, 4.9e-08, 2.12764378762e-07, 4.92e-08, 2.13867303846e-07, 4.94e-08, 2.14990382342e-07, 4.96e-08, 2.1613343363e-07, 4.98e-08, 2.17296254591e-07, 5e-08, 2.18478618627e-07, 5.02e-08, 2.19680274676e-07, 5.04e-08, 2.2090094621e-07, 5.06e-08, 2.2214033022e-07, 5.08e-08, 2.23398096208e-07, 5.1e-08, 2.24673885157e-07, 5.12e-08, 2.25967308522e-07, 5.14e-08, 2.27277947212e-07, 5.16e-08, 2.28605350591e-07, 5.18e-08, 2.29949035485e-07, 5.2e-08, 2.31308485221e-07, 5.22e-08, 2.3268314868e-07, 5.24e-08, 2.34072439388e-07, 5.26e-08, 2.35475734645e-07, 5.28e-08, 2.36892374699e-07, 5.3e-08, 2.3832166197e-07, 5.32e-08, 2.39762860333e-07, 5.34e-08, 2.41215194476e-07, 5.36e-08, 2.42677849322e-07, 5.38e-08, 2.44149969545e-07, 5.4e-08, 2.45630659173e-07, 5.42e-08, 2.47118981294e-07, 5.44e-08, 2.48613957873e-07, 5.46e-08, 2.50114569691e-07, 5.48e-08, 2.51619756402e-07, 5.5e-08, 2.53128416744e-07, 5.52e-08, 2.54639408884e-07, 5.54e-08, 2.56151550922e-07, 5.56e-08, 2.57663621563e-07, 5.58e-08, 2.59174360954e-07, 5.6e-08, 2.6068247171e-07, 5.62e-08, 2.62186620115e-07, 5.64e-08, 2.63685437529e-07, 5.66e-08, 2.65177521983e-07, 5.68e-08, 2.66661439989e-07, 5.7e-08, 2.68135728545e-07, 5.72e-08, 2.69598897357e-07, 5.74e-08, 2.71049431274e-07, 5.76e-08, 2.72485792929e-07, 5.78e-08, 2.73906425591e-07, 5.8e-08, 2.75309756228e-07, 5.82e-08, 2.76694198764e-07, 5.84e-08, 2.78058157536e-07, 5.86e-08, 2.7940003094e-07, 5.88e-08, 2.8071821525e-07, 5.9e-08, 2.82011108606e-07, 5.92e-08, 2.8327711515e-07, 5.94e-08, 2.84514649299e-07, 5.96e-08, 2.85722140141e-07, 5.98e-08, 2.86898035926e-07, 6e-08, 2.88040808637e-07, 6.02e-08, 2.89148958619e-07, 6.04e-08, 2.90221019243e-07, 6.06e-08, 2.91255561571e-07, 6.08e-08, 2.92251199017e-07, 6.1e-08, 2.93206591947e-07, 6.12e-08, 2.94120452221e-07, 6.14e-08, 2.9499154763e-07, 6.16e-08, 2.95818706204e-07, 6.18e-08, 2.96600820368e-07, 6.2e-08, 2.97336850915e-07, 6.22e-08, 2.98025830767e-07, 6.24e-08, 2.98666868504e-07, 6.26e-08, 2.99259151632e-07, 6.28e-08, 2.99801949571e-07, 6.3e-08, 3.00294616332e-07, 6.32e-08, 3.00736592883e-07, 6.34e-08, 3.01127409165e-07, 6.36e-08, 3.01466685756e-07, 6.38e-08, 3.01754135178e-07, 6.4e-08, 3.01989562812e-07, 6.42e-08, 3.0217286745e-07, 6.44e-08, 3.02304041447e-07, 6.46e-08, 3.02383170499e-07, 6.48e-08, 3.0241043303e-07, 6.5e-08, 3.02386099209e-07, 6.52e-08, 3.02310529592e-07, 6.54e-08, 3.02184173413e-07, 6.56e-08, 3.02007566522e-07, 6.58e-08, 3.01781329005e-07, 6.6e-08, 3.01506162487e-07, 6.62e-08, 3.01182847147e-07, 6.64e-08, 3.00812238468e-07, 6.66e-08, 3.00395263743e-07, 6.68e-08, 2.99932918356e-07, 6.7e-08, 2.99426261881e-07, 6.72e-08, 2.98876414e-07, 6.74e-08, 2.98284550296e-07, 6.76e-08, 2.97651897923e-07, 6.78e-08, 2.96979731192e-07, 6.8e-08, 2.96269367103e-07, 6.82e-08, 2.95522160836e-07, 6.84e-08, 2.9473950124e-07, 6.86e-08, 2.93922806341e-07, 6.88e-08, 2.93073518876e-07, 6.9e-08, 2.92193101907e-07, 6.92e-08, 2.91283034499e-07, 6.94e-08, 2.90344807511e-07, 6.96e-08, 2.893799195e-07, 6.98e-08, 2.88389872753e-07, 7e-08, 2.87376169476e-07, 7.02e-08, 2.86340308132e-07, 7.04e-08, 2.85283779951e-07, 7.06e-08, 2.84208065621e-07, 7.08e-08, 2.83114632158e-07, 7.1e-08, 2.8200492997e-07, 7.12e-08, 2.80880390108e-07, 7.14e-08, 2.79742421719e-07, 7.16e-08, 2.7859240969e-07, 7.18e-08, 2.77431712492e-07, 7.2e-08, 2.76261660214e-07, 7.22e-08, 2.75083552794e-07, 7.24e-08, 2.73898658427e-07, 7.26e-08, 2.72708212166e-07, 7.28e-08, 2.715134147e-07, 7.3e-08, 2.70315431294e-07, 7.32e-08, 2.69115390905e-07, 7.34e-08, 2.67914385447e-07, 7.36e-08, 2.66713469212e-07, 7.38e-08, 2.65513658431e-07, 7.4e-08, 2.64315930966e-07, 7.42e-08, 2.63121226136e-07, 7.44e-08, 2.61930444655e-07, 7.46e-08, 2.60744448677e-07, 7.48e-08, 2.59564061953e-07, 7.5e-08, 2.58390070072e-07, 7.52e-08, 2.5722322079e-07, 7.54e-08, 2.56064224439e-07, 7.56e-08, 2.54913754407e-07, 7.58e-08, 2.53772447677e-07, 7.6e-08, 2.52640905424e-07, 7.62e-08, 2.51519693669e-07, 7.64e-08, 2.50409343962e-07, 7.66e-08, 2.49310354116e-07, 7.68e-08, 2.48223188967e-07, 7.7e-08, 2.47148281158e-07, 7.72e-08, 2.46086031949e-07, 7.74e-08, 2.45036812044e-07, 7.76e-08, 2.44000962425e-07, 7.78e-08, 2.42978795204e-07, 7.8e-08, 2.41970594467e-07, 7.82e-08, 2.40976617135e-07, 7.84e-08, 2.3999709381e-07, 7.86e-08, 2.39032229625e-07, 7.88e-08, 2.38082205083e-07, 7.9e-08, 2.37147176894e-07, 7.92e-08, 2.36227278789e-07, 7.94e-08, 2.35322622336e-07, 7.96e-08, 2.34433297729e-07, 7.98e-08, 2.33559374573e-07, 8e-08, 2.32700902645e-07, 8.02e-08, 2.3185791264e-07, 8.04e-08, 2.310304169e-07, 8.06e-08, 2.30218410126e-07, 8.08e-08, 2.29421870069e-07, 8.1e-08, 2.28640758199e-07, 8.12e-08, 2.27875020366e-07, 8.14e-08, 2.27124587425e-07, 8.16e-08, 2.2638937586e-07, 8.18e-08, 2.25669288378e-07, 8.2e-08, 2.24964214483e-07, 8.22e-08, 2.24274031043e-07, 8.24e-08, 2.2359860283e-07, 8.26e-08, 2.22937783042e-07, 8.28e-08, 2.22291413817e-07, 8.3e-08, 2.21659326725e-07, 8.32e-08, 2.21041343244e-07, 8.34e-08, 2.20437275222e-07, 8.36e-08, 2.19846925332e-07, 8.38e-08, 2.19270087502e-07, 8.4e-08, 2.18706547343e-07, 8.42e-08, 2.1815608256e-07, 8.44e-08, 2.17618463353e-07, 8.46e-08, 2.1709345281e-07, 8.48e-08, 2.16580807287e-07, 8.5e-08, 2.16080276785e-07, 8.52e-08, 2.15591605316e-07, 8.54e-08, 2.15114531261e-07, 8.56e-08, 2.14648787725e-07, 8.58e-08, 2.14194102883e-07, 8.6e-08, 2.13750200328e-07, 8.62e-08, 2.13316799407e-07, 8.64e-08, 2.12893615559e-07, 8.66e-08, 2.12480360648e-07, 8.68e-08, 2.12076743295e-07, 8.7e-08, 2.1168246921e-07, 8.72e-08, 2.1129724152e-07, 8.74e-08, 2.10920761097e-07, 8.76e-08, 2.10552726891e-07, 8.78e-08, 2.10192836255e-07, 8.8e-08, 2.09840785279e-07, 8.82e-08, 2.0949626912e-07, 8.84e-08, 2.09158982333e-07, 8.86e-08, 2.0882861921e-07, 8.88e-08, 2.08504874113e-07, 8.9e-08, 2.08187441813e-07, 8.92e-08, 2.0787601783e-07, 8.94e-08, 2.07570298775e-07, 8.96e-08, 2.07269982695e-07, 8.98e-08, 2.06974769417e-07, 9e-08, 2.06684360898e-07, 9.02e-08, 2.0639846157e-07, 9.04e-08, 2.06116778693e-07, 9.06e-08, 2.05839022706e-07, 9.08e-08, 2.05564907577e-07, 9.1e-08, 2.05294151153e-07, 9.12e-08, 2.05026475516e-07, 9.14e-08, 2.04761607325e-07, 9.16e-08, 2.04499278173e-07, 9.18e-08, 2.04239224928e-07, 9.2e-08, 2.03981190077e-07, 9.22e-08, 2.03724922069e-07, 9.24e-08, 2.03470175648e-07, 9.26e-08, 2.03216712185e-07, 9.28e-08, 2.02964300006e-07, 9.3e-08, 2.02712714708e-07, 9.32e-08, 2.02461739471e-07, 9.34e-08, 2.02211165364e-07, 9.36e-08, 2.01960791639e-07, 9.38e-08, 2.01710426017e-07, 9.4e-08, 2.01459884959e-07, 9.42e-08, 2.01208993937e-07, 9.44e-08, 2.00957587677e-07, 9.46e-08, 2.00705510405e-07, 9.48e-08, 2.00452616066e-07, 9.5e-08, 2.00198768538e-07, 9.52e-08, 1.99943841828e-07, 9.54e-08, 1.99687720247e-07, 9.56e-08, 1.99430298582e-07, 9.58e-08, 1.99171482233e-07, 9.6e-08, 1.98911187348e-07, 9.62e-08, 1.98649340935e-07, 9.64e-08, 1.98385880952e-07, 9.66e-08, 1.98120756381e-07, 9.68e-08, 1.97853927287e-07, 9.7e-08, 1.97585364852e-07, 9.72e-08, 1.97315051395e-07, 9.74e-08, 1.97042980365e-07, 9.76e-08, 1.96769156324e-07, 9.78e-08, 1.96493594907e-07, 9.8e-08, 1.96216322758e-07, 9.82e-08, 1.95937377456e-07, 9.84e-08, 1.95656807417e-07, 9.86e-08, 1.95374671775e-07, 9.88e-08, 1.95091040256e-07, 9.9e-08, 1.94805993021e-07, 9.92e-08, 1.94519620505e-07, 9.94e-08, 1.94232023228e-07, 9.96e-08, 1.93943311603e-07, 9.98e-08, 1.93653605715e-07, 1e-07, 1.93363035102e-07, 1.002e-07, 1.93071738508e-07, 1.004e-07, 1.92779863637e-07, 1.006e-07, 1.9248756688e-07, 1.008e-07, 1.92195013052e-07, 1.01e-07, 1.91902375098e-07, 1.012e-07, 1.91609833807e-07, 1.014e-07, 1.91317577508e-07, 1.016e-07, 1.91025801767e-07, 1.018e-07, 1.90734709074e-07, 1.02e-07, 1.90444508523e-07, 1.022e-07, 1.90155415497e-07, 1.024e-07, 1.89867651344e-07, 1.026e-07, 1.89581443048e-07, 1.028e-07, 1.89297022912e-07, 1.03e-07, 1.89014628227e-07, 1.032e-07, 1.8873450095e-07, 1.034e-07, 1.88456887387e-07, 1.036e-07, 1.88182037866e-07, 1.038e-07, 1.87910206432e-07, 1.04e-07, 1.87641650529e-07, 1.042e-07, 1.873766307e-07, 1.044e-07, 1.87115410284e-07, 1.046e-07, 1.86858255127e-07, 1.048e-07, 1.86605433294e-07, 1.05e-07, 1.86357214791e-07, 1.052e-07, 1.86113871297e-07, 1.054e-07, 1.85875675902e-07, 1.056e-07, 1.85642902853e-07, 1.058e-07, 1.85415827313e-07, 1.06e-07, 1.85194725128e-07, 1.062e-07, 1.84979872601e-07, 1.064e-07, 1.84771546281e-07, 1.066e-07, 1.84570022757e-07, 1.068e-07, 1.84375578467e-07, 1.07e-07, 1.84188489513e-07, 1.072e-07, 1.8400903149e-07, 1.074e-07, 1.8383747932e-07, 1.076e-07, 1.83674107105e-07, 1.078e-07, 1.83519187981e-07, 1.08e-07, 1.83372993984e-07, 1.082e-07, 1.83235795933e-07, 1.084e-07, 1.83107863309e-07, 1.086e-07, 1.82989464156e-07, 1.088e-07, 1.82880864984e-07, 1.09e-07, 1.82782330681e-07, 1.092e-07, 1.82694124435e-07, 1.094e-07, 1.82616507665e-07, 1.096e-07, 1.82549739951e-07, 1.098e-07, 1.82494078987e-07, 1.1e-07, 1.82449780522e-07, 1.102e-07, 1.82417098321e-07, 1.104e-07, 1.82396284122e-07, 1.106e-07, 1.8238758761e-07, 1.108e-07, 1.82391256381e-07, 1.11e-07, 1.82407535918e-07, 1.112e-07, 1.82436669575e-07, 1.114e-07, 1.82478898552e-07, 1.116e-07, 1.82534461883e-07, 1.118e-07, 1.82603596421e-07, 1.12e-07, 1.82686536824e-07, 1.122e-07, 1.82783515543e-07, 1.124e-07, 1.82894762812e-07, 1.126e-07, 1.83020506632e-07, 1.128e-07, 1.83160972758e-07, 1.13e-07, 1.83316384684e-07, 1.132e-07, 1.83486963626e-07, 1.134e-07, 1.83672928498e-07, 1.136e-07, 1.8387449589e-07, 1.138e-07, 1.84091880037e-07, 1.14e-07, 1.84325292786e-07, 1.142e-07, 1.84574943557e-07, 1.144e-07, 1.84841039296e-07, 1.146e-07, 1.85123784423e-07, 1.148e-07, 1.85423380771e-07, 1.15e-07, 1.85740027519e-07, 1.152e-07, 1.86073921114e-07, 1.154e-07, 1.86425255183e-07, 1.156e-07, 1.86794220436e-07, 1.158e-07, 1.87181004558e-07, 1.16e-07, 1.8758579209e-07, 1.162e-07, 1.88008764292e-07, 1.164e-07, 1.88450099004e-07, 1.166e-07, 1.88909970481e-07, 1.168e-07, 1.89388549221e-07, 1.17e-07, 1.89886001773e-07, 1.172e-07, 1.90402490536e-07, 1.174e-07, 1.90938173533e-07, 1.176e-07, 1.91493204169e-07, 1.178e-07, 1.9206773098e-07, 1.18e-07, 1.92661897347e-07, 1.182e-07, 1.93275841204e-07, 1.184e-07, 1.9390969472e-07, 1.186e-07, 1.94563583957e-07, 1.188e-07, 1.95237628515e-07, 1.19e-07, 1.95931941141e-07, 1.192e-07, 1.9664662733e-07, 1.194e-07, 1.97381784891e-07, 1.196e-07, 1.9813750349e-07, 1.198e-07, 1.98913864175e-07, 1.2e-07, 1.99710938867e-07, 1.202e-07, 2.00528789829e-07, 1.204e-07, 2.0136746911e-07, 1.206e-07, 2.02227017955e-07, 1.208e-07, 2.03107466201e-07, 1.21e-07, 2.04008831628e-07, 1.212e-07, 2.04931119298e-07, 1.214e-07, 2.0587432086e-07, 1.216e-07, 2.06838413824e-07, 1.218e-07, 2.07823360816e-07, 1.22e-07, 2.08829108798e-07, 1.222e-07, 2.09855588266e-07, 1.224e-07, 2.1090271242e-07, 1.226e-07, 2.1197037631e-07, 1.228e-07, 2.13058455957e-07, 1.23e-07, 2.14166807451e-07, 1.232e-07, 2.15295266027e-07, 1.234e-07, 2.16443645119e-07, 1.236e-07, 2.17611735403e-07, 1.238e-07, 2.18799303812e-07, 1.24e-07, 2.20006092546e-07, 1.242e-07, 2.21231818068e-07, 1.244e-07, 2.22476170091e-07, 1.246e-07, 2.23738810559e-07, 1.248e-07, 2.25019372632e-07, 1.25e-07, 2.26317459662e-07, 1.252e-07, 2.27632644188e-07, 1.254e-07, 2.28964466937e-07, 1.256e-07, 2.30312435837e-07, 1.258e-07, 2.31676025058e-07, 1.26e-07, 2.3305467408e-07, 1.262e-07, 2.34447786787e-07, 1.264e-07, 2.35854730614e-07, 1.266e-07, 2.37274835726e-07, 1.268e-07, 2.38707394265e-07, 1.27e-07, 2.40151659647e-07, 1.272e-07, 2.41606845939e-07, 1.274e-07, 2.43072127303e-07, 1.276e-07, 2.44546637538e-07, 1.278e-07, 2.46029469705e-07, 1.28e-07, 2.47519675869e-07, 1.282e-07, 2.49016266938e-07, 1.284e-07, 2.50518212642e-07, 1.286e-07, 2.52024441627e-07, 1.288e-07, 2.53533841698e-07, 1.29e-07, 2.55045260211e-07, 1.292e-07, 2.56557504619e-07, 1.294e-07, 2.58069343186e-07, 1.296e-07, 2.59579505877e-07, 1.298e-07, 2.61086685425e-07, 1.3e-07, 2.62589538597e-07, 1.302e-07, 2.64086687639e-07, 1.304e-07, 2.65576721937e-07, 1.306e-07, 2.67058199871e-07, 1.308e-07, 2.68529650889e-07, 1.31e-07, 2.69989577776e-07, 1.312e-07, 2.71436459149e-07, 1.314e-07, 2.72868752155e-07, 1.316e-07, 2.74284895377e-07, 1.318e-07, 2.75683311954e-07, 1.32e-07, 2.77062412889e-07, 1.322e-07, 2.78420600558e-07, 1.324e-07, 2.79756272407e-07, 1.326e-07, 2.81067824812e-07, 1.328e-07, 2.82353657111e-07, 1.33e-07, 2.83612175781e-07, 1.332e-07, 2.8484179874e-07, 1.334e-07, 2.86040959775e-07, 1.336e-07, 2.87208113056e-07, 1.338e-07, 2.88341737723e-07, 1.34e-07, 2.89440342528e-07, 1.342e-07, 2.905024705e-07, 1.344e-07, 2.91526703616e-07, 1.346e-07, 2.92511667442e-07, 1.348e-07, 2.93456035727e-07, 1.35e-07, 2.94358534912e-07, 1.352e-07, 2.95217948542e-07, 1.354e-07, 2.96033121532e-07, 1.356e-07, 2.96802964277e-07, 1.358e-07, 2.97526456573e-07, 1.36e-07, 2.98202651316e-07, 1.362e-07, 2.98830677961e-07, 1.364e-07, 2.99409745723e-07, 1.366e-07, 2.99939146479e-07, 1.368e-07, 3.00418257365e-07, 1.37e-07, 3.00846543047e-07, 1.372e-07, 3.01223557649e-07, 1.374e-07, 3.01548946318e-07, 1.376e-07, 3.01822446427e-07, 1.378e-07, 3.02043888395e-07, 1.38e-07, 3.02213196131e-07, 1.382e-07, 3.02330387083e-07, 1.384e-07, 3.02395571914e-07, 1.386e-07, 3.02408953789e-07, 1.388e-07, 3.02370827289e-07, 1.39e-07, 3.02281576955e-07, 1.392e-07, 3.0214167549e-07, 1.394e-07, 3.01951681602e-07, 1.396e-07, 3.01712237542e-07, 1.398e-07, 3.01424066327e-07, 1.4e-07, 3.0108796868e-07, 1.402e-07, 3.00704819713e-07, 1.404e-07, 3.0027556537e-07, 1.406e-07, 2.99801218658e-07, 1.408e-07, 2.99282855691e-07, 1.41e-07, 2.98721611577e-07, 1.412e-07, 2.98118676172e-07, 1.414e-07, 2.97475289723e-07, 1.416e-07, 2.96792738443e-07, 1.418e-07, 2.96072350022e-07, 1.42e-07, 2.95315489123e-07, 1.422e-07, 2.94523552867e-07, 1.424e-07, 2.93697966348e-07, 1.426e-07, 2.92840178187e-07, 1.428e-07, 2.91951656163e-07, 1.43e-07, 2.91033882915e-07, 1.432e-07, 2.90088351766e-07, 1.434e-07, 2.89116562658e-07, 1.436e-07, 2.88120018224e-07, 1.438e-07, 2.87100220017e-07, 1.44e-07, 2.86058664895e-07, 1.442e-07, 2.84996841575e-07, 1.444e-07, 2.83916227375e-07, 1.446e-07, 2.82818285133e-07, 1.448e-07, 2.81704460322e-07, 1.45e-07, 2.80576178355e-07, 1.452e-07, 2.79434842091e-07, 1.454e-07, 2.78281829529e-07, 1.456e-07, 2.77118491707e-07, 1.458e-07, 2.75946150785e-07, 1.46e-07, 2.74766098329e-07, 1.462e-07, 2.73579593768e-07, 1.464e-07, 2.72387863043e-07, 1.466e-07, 2.71192097431e-07, 1.468e-07, 2.6999345253e-07, 1.47e-07, 2.68793047419e-07, 1.472e-07, 2.67591963965e-07, 1.474e-07, 2.6639124628e-07, 1.476e-07, 2.65191900319e-07, 1.478e-07, 2.63994893612e-07, 1.48e-07, 2.62801155115e-07, 1.482e-07, 2.61611575181e-07, 1.484e-07, 2.60427005638e-07, 1.486e-07, 2.59248259965e-07, 1.488e-07, 2.58076113559e-07, 1.49e-07, 2.56911304087e-07, 1.492e-07, 2.55754531914e-07, 1.494e-07, 2.546064606e-07, 1.496e-07, 2.53467717455e-07, 1.498e-07, 2.52338894153e-07, 1.5e-07, 2.5122054739e-07, 1.502e-07, 2.50113199589e-07, 1.504e-07, 2.49017339633e-07, 1.506e-07, 2.47933423639e-07, 1.508e-07, 2.46861875745e-07, 1.51e-07, 2.45803088928e-07, 1.512e-07, 2.4475742583e-07, 1.514e-07, 2.437252196e-07, 1.516e-07, 2.42706774742e-07, 1.518e-07, 2.41702367969e-07, 1.52e-07, 2.40712249051e-07, 1.522e-07, 2.39736641671e-07, 1.524e-07, 2.38775744268e-07, 1.526e-07, 2.37829730878e-07, 1.528e-07, 2.3689875196e-07, 1.53e-07, 2.35982935219e-07, 1.532e-07, 2.35082386406e-07, 1.534e-07, 2.34197190115e-07, 1.536e-07, 2.33327410552e-07, 1.538e-07, 2.32473092299e-07, 1.54e-07, 2.31634261054e-07, 1.542e-07, 2.30810924356e-07, 1.544e-07, 2.30003072287e-07, 1.546e-07, 2.29210678163e-07, 1.548e-07, 2.28433699198e-07, 1.55e-07, 2.27672077154e-07, 1.552e-07, 2.2692573897e-07, 1.554e-07, 2.26194597374e-07, 1.556e-07, 2.25478551471e-07, 1.558e-07, 2.24777487321e-07, 1.56e-07, 2.24091278492e-07, 1.562e-07, 2.23419786597e-07, 1.564e-07, 2.22762861816e-07, 1.566e-07, 2.22120343404e-07, 1.568e-07, 2.21492060174e-07, 1.57e-07, 2.20877830974e-07, 1.572e-07, 2.20277465147e-07, 1.574e-07, 2.19690762975e-07, 1.576e-07, 2.19117516113e-07, 1.578e-07, 2.18557508009e-07, 1.58e-07, 2.18010514314e-07, 1.582e-07, 2.17476303282e-07, 1.584e-07, 2.16954636156e-07, 1.586e-07, 2.1644526755e-07, 1.588e-07, 2.15947945822e-07, 1.59e-07, 2.15462413437e-07, 1.592e-07, 2.14988407325e-07, 1.594e-07, 2.14525659233e-07, 1.596e-07, 2.14073896074e-07, 1.598e-07, 2.13632840267e-07, 1.6e-07, 2.13202210078e-07, 1.602e-07, 2.12781719952e-07, 1.604e-07, 2.12371080851e-07, 1.606e-07, 2.11970000582e-07, 1.608e-07, 2.11578184129e-07, 1.61e-07, 2.11195333982e-07, 1.612e-07, 2.10821150465e-07, 1.614e-07, 2.10455332067e-07, 1.616e-07, 2.10097575768e-07, 1.618e-07, 2.09747577375e-07, 1.62e-07, 2.09405031852e-07, 1.622e-07, 2.0906963365e-07, 1.624e-07, 2.08741077047e-07, 1.626e-07, 2.08419056481e-07, 1.628e-07, 2.08103266891e-07, 1.63e-07, 2.07793404055e-07, 1.632e-07, 2.07489164937e-07, 1.634e-07, 2.07190248028e-07, 1.636e-07, 2.06896353691e-07, 1.638e-07, 2.06607184514e-07, 1.64e-07, 2.06322445653e-07, 1.642e-07, 2.06041845189e-07, 1.644e-07, 2.05765094472e-07, 1.646e-07, 2.05491908477e-07, 1.648e-07, 2.05222006154e-07, 1.65e-07, 2.04955110778e-07, 1.652e-07, 2.04690950301e-07, 1.654e-07, 2.04429257695e-07, 1.656e-07, 2.04169771304e-07, 1.658e-07, 2.03912235183e-07, 1.66e-07, 2.03656399437e-07, 1.662e-07, 2.03402020556e-07, 1.664e-07, 2.03148861748e-07, 1.666e-07, 2.02896693259e-07, 1.668e-07, 2.0264529269e-07, 1.67e-07, 2.02394445312e-07, 1.672e-07, 2.0214394436e-07, 1.674e-07, 2.01893591332e-07, 1.676e-07, 2.01643196268e-07, 1.678e-07, 2.01392578024e-07, 1.68e-07, 2.01141564531e-07, 1.682e-07, 2.00889993043e-07, 1.684e-07, 2.00637710373e-07, 1.686e-07, 2.00384573111e-07, 1.688e-07, 2.00130447838e-07, 1.69e-07, 1.99875211308e-07, 1.692e-07, 1.9961875063e-07, 1.694e-07, 1.99360963425e-07, 1.696e-07, 1.99101757967e-07, 1.698e-07, 1.9884105331e-07, 1.7e-07, 1.98578779391e-07, 1.702e-07, 1.98314877121e-07, 1.704e-07, 1.98049298454e-07, 1.706e-07, 1.97782006435e-07, 1.708e-07, 1.97512975236e-07, 1.71e-07, 1.97242190163e-07, 1.712e-07, 1.96969647652e-07, 1.714e-07, 1.96695355243e-07, 1.716e-07, 1.96419331531e-07, 1.718e-07, 1.96141606105e-07, 1.72e-07, 1.95862219463e-07, 1.722e-07, 1.9558122291e-07, 1.724e-07, 1.95298678438e-07, 1.726e-07, 1.95014658588e-07, 1.728e-07, 1.94729246298e-07, 1.73e-07, 1.94442534727e-07, 1.732e-07, 1.94154627071e-07, 1.734e-07, 1.93865636361e-07, 1.736e-07, 1.93575685244e-07, 1.738e-07, 1.93284905751e-07, 1.74e-07, 1.92993439058e-07, 1.742e-07, 1.92701435227e-07, 1.744e-07, 1.92409052937e-07, 1.746e-07, 1.92116459214e-07, 1.748e-07, 1.91823829138e-07, 1.75e-07, 1.91531345551e-07, 1.752e-07, 1.91239198756e-07, 1.754e-07, 1.90947586208e-07, 1.756e-07, 1.90656712201e-07, 1.758e-07, 1.90366787548e-07, 1.76e-07, 1.90078029267e-07, 1.762e-07, 1.89790660249e-07, 1.764e-07, 1.89504908938e-07, 1.766e-07, 1.89221009008e-07, 1.768e-07, 1.88939199034e-07, 1.77e-07, 1.88659722173e-07, 1.772e-07, 1.8838282584e-07, 1.774e-07, 1.88108761393e-07, 1.776e-07, 1.87837783819e-07, 1.778e-07, 1.87570151424e-07, 1.78e-07, 1.8730612553e-07, 1.782e-07, 1.87045970178e-07, 1.784e-07, 1.86789951837e-07, 1.786e-07, 1.8653833912e-07, 1.788e-07, 1.86291402509e-07, 1.79e-07, 1.86049414086e-07, 1.792e-07, 1.85812647276e-07, 1.794e-07, 1.85581376596e-07, 1.796e-07, 1.85355877415e-07, 1.798e-07, 1.85136425723e-07, 1.8e-07, 1.8492329791e-07, 1.802e-07, 1.84716770554e-07, 1.804e-07, 1.84517120223e-07, 1.806e-07, 1.84324623282e-07, 1.808e-07, 1.84139555714e-07, 1.81e-07, 1.83962192947e-07, 1.812e-07, 1.837928097e-07, 1.814e-07, 1.83631679829e-07, 1.816e-07, 1.83479076185e-07, 1.818e-07, 1.83335270492e-07, 1.82e-07, 1.83200533218e-07, 1.822e-07, 1.83075133469e-07, 1.824e-07, 1.82959338887e-07, 1.826e-07, 1.82853415554e-07, 1.828e-07, 1.82757627909e-07, 1.83e-07, 1.82672238673e-07, 1.832e-07, 1.82597508775e-07, 1.834e-07, 1.82533697297e-07, 1.836e-07, 1.82481061413e-07, 1.838e-07, 1.82439856345e-07, 1.84e-07, 1.82410335316e-07, 1.842e-07, 1.82392749518e-07, 1.844e-07, 1.82387348076e-07, 1.846e-07, 1.82394378022e-07, 1.848e-07, 1.82414084269e-07, 1.85e-07, 1.82446709595e-07, 1.852e-07, 1.82492494621e-07, 1.854e-07, 1.82551677795e-07, 1.856e-07, 1.82624495382e-07, 1.858e-07, 1.8271118145e-07, 1.86e-07, 1.82811967856e-07, 1.862e-07, 1.82927084236e-07, 1.864e-07, 1.83056757987e-07, 1.866e-07, 1.83201214262e-07, 1.868e-07, 1.83360675945e-07, 1.87e-07, 1.83535363634e-07, 1.872e-07, 1.83725495624e-07, 1.874e-07, 1.83931287874e-07, 1.876e-07, 1.84152953983e-07, 1.878e-07, 1.8439070515e-07, 1.88e-07, 1.84644750136e-07, 1.882e-07, 1.84915295214e-07, 1.884e-07, 1.85202544116e-07, 1.886e-07, 1.8550669797e-07, 1.888e-07, 1.85827955229e-07, 1.89e-07, 1.86166511593e-07, 1.892e-07, 1.86522559914e-07, 1.894e-07, 1.86896290103e-07, 1.896e-07, 1.87287889013e-07, 1.898e-07, 1.87697540316e-07, 1.9e-07, 1.88125424372e-07, 1.902e-07, 1.88571718073e-07, 1.904e-07, 1.89036594683e-07, 1.906e-07, 1.89520223659e-07, 1.908e-07, 1.90022770458e-07, 1.91e-07, 1.90544396327e-07, 1.912e-07, 1.91085258072e-07, 1.914e-07, 1.9164550782e-07, 1.916e-07, 1.92225292748e-07, 1.918e-07, 1.92824754806e-07, 1.92e-07, 1.93444030414e-07, 1.922e-07, 1.94083250134e-07, 1.924e-07, 1.9474253833e-07, 1.926e-07, 1.95422012802e-07, 1.928e-07, 1.9612178439e-07, 1.93e-07, 1.9684195657e-07, 1.932e-07, 1.9758262501e-07, 1.934e-07, 1.98343877112e-07, 1.936e-07, 1.99125791523e-07, 1.938e-07, 1.99928437626e-07, 1.94e-07, 2.00751874998e-07, 1.942e-07, 2.01596152846e-07, 1.944e-07, 2.02461309414e-07, 1.946e-07, 2.03347371366e-07, 1.948e-07, 2.04254353136e-07, 1.95e-07, 2.05182256253e-07, 1.952e-07, 2.06131068644e-07, 1.954e-07, 2.07100763898e-07, 1.956e-07, 2.08091300513e-07, 1.958e-07, 2.09102621112e-07, 1.96e-07, 2.10134651629e-07, 1.962e-07, 2.11187300479e-07, 1.964e-07, 2.12260457689e-07, 1.966e-07, 2.13353994021e-07, 1.968e-07, 2.14467760057e-07, 1.97e-07, 2.15601585275e-07, 1.972e-07, 2.16755277093e-07, 1.974e-07, 2.17928619912e-07, 1.976e-07, 2.19121374123e-07, 1.978e-07, 2.20333275116e-07, 1.98e-07, 2.21564032273e-07, 1.982e-07, 2.22813327954e-07, 1.984e-07, 2.24080816476e-07, 1.986e-07, 2.25366123095e-07, 1.988e-07, 2.26668842994e-07, 1.99e-07, 2.27988540268e-07, 1.992e-07, 2.29324746935e-07, 1.994e-07, 2.30676961954e-07, 1.996e-07, 2.32044650276e-07, 1.998e-07, 2.3342724191e-07, 2e-07, 2.34824131039e-07, 2.002e-07, 2.36234675172e-07, 2.004e-07, 2.3765819434e-07, 2.006e-07, 2.39093970353e-07, 2.008e-07, 2.40541246125e-07, 2.01e-07, 2.4199922506e-07, 2.012e-07, 2.43467070527e-07, 2.014e-07, 2.44943905423e-07, 2.016e-07, 2.46428811824e-07, 2.018e-07, 2.47920830758e-07, 2.02e-07, 2.49418962077e-07, 2.022e-07, 2.50922164467e-07, 2.024e-07, 2.5242935558e-07, 2.026e-07, 2.5393941232e-07, 2.028e-07, 2.5545117127e-07, 2.03e-07, 2.56963429286e-07, 2.032e-07, 2.58474944257e-07, 2.034e-07, 2.59984436039e-07, 2.036e-07, 2.61490587582e-07, 2.038e-07, 2.62992046233e-07, 2.04e-07, 2.64487425247e-07, 2.042e-07, 2.65975305495e-07, 2.044e-07, 2.6745423738e-07, 2.046e-07, 2.6892274296e-07, 2.048e-07, 2.70379318279e-07, 2.05e-07, 2.71822435917e-07, 2.052e-07, 2.73250547743e-07, 2.054e-07, 2.74662087881e-07, 2.056e-07, 2.76055475878e-07, 2.058e-07, 2.77429120069e-07, 2.06e-07, 2.78781421138e-07, 2.062e-07, 2.80110775855e-07, 2.064e-07, 2.8141558099e-07, 2.066e-07, 2.82694237382e-07, 2.068e-07, 2.83945154151e-07, 2.07e-07, 2.85166753036e-07, 2.072e-07, 2.8635747285e-07, 2.074e-07, 2.87515774011e-07, 2.076e-07, 2.88640143151e-07, 2.078e-07, 2.89729097765e-07, 2.08e-07, 2.9078119088e-07, 2.082e-07, 2.91795015718e-07, 2.084e-07, 2.92769210332e-07, 2.086e-07, 2.93702462176e-07, 2.088e-07, 2.94593512593e-07, 2.09e-07, 2.95441161187e-07, 2.092e-07, 2.96244270057e-07, 2.094e-07, 2.97001767849e-07, 2.096e-07, 2.97712653629e-07, 2.098e-07, 2.98376000514e-07, 2.1e-07, 2.98990959069e-07, 2.102e-07, 2.99556760425e-07, 2.104e-07, 3.00072719102e-07, 2.106e-07, 3.00538235526e-07, 2.108e-07, 3.00952798201e-07, 2.11e-07, 3.01315985547e-07, 2.112e-07, 3.01627467364e-07, 2.114e-07, 3.01887005939e-07, 2.116e-07, 3.02094456758e-07, 2.118e-07, 3.0224976885e-07, 2.12e-07, 3.02352984735e-07, 2.122e-07, 3.02404239992e-07, 2.124e-07, 3.02403762447e-07, 2.126e-07, 3.02351870986e-07, 2.128e-07, 3.0224897401e-07, 2.13e-07, 3.02095567532e-07, 2.132e-07, 3.01892232941e-07, 2.134e-07, 3.01639634455e-07, 2.136e-07, 3.0133851626e-07, 2.138e-07, 3.00989699385e-07, 2.14e-07, 3.00594078314e-07, 2.142e-07, 3.00152617371e-07, 2.144e-07, 2.99666346898e-07, 2.146e-07, 2.99136359258e-07, 2.148e-07, 2.98563804675e-07, 2.15e-07, 2.97949886962e-07, 2.152e-07, 2.97295859145e-07, 2.154e-07, 2.96603019011e-07, 2.156e-07, 2.9587270462e-07, 2.158e-07, 2.95106289788e-07, 2.16e-07, 2.94305179585e-07, 2.162e-07, 2.93470805855e-07, 2.164e-07, 2.92604622788e-07, 2.166e-07, 2.91708102569e-07, 2.168e-07, 2.9078273111e-07, 2.17e-07, 2.89830003906e-07, 2.172e-07, 2.88851421998e-07, 2.174e-07, 2.87848488096e-07, 2.176e-07, 2.8682270284e-07, 2.178e-07, 2.85775561232e-07, 2.18e-07, 2.84708549243e-07, 2.182e-07, 2.83623140598e-07, 2.184e-07, 2.8252079375e-07, 2.186e-07, 2.81402949043e-07, 2.188e-07, 2.80271026072e-07, 2.19e-07, 2.7912642124e-07, 2.192e-07, 2.7797050551e-07, 2.194e-07, 2.76804622345e-07, 2.196e-07, 2.75630085856e-07, 2.198e-07, 2.74448179124e-07, 2.2e-07, 2.73260152714e-07, 2.202e-07, 2.72067223372e-07, 2.204e-07, 2.70870572888e-07, 2.206e-07, 2.69671347135e-07, 2.208e-07, 2.68470655264e-07, 2.21e-07, 2.67269569053e-07, 2.212e-07, 2.66069122406e-07, 2.214e-07, 2.64870310985e-07, 2.216e-07, 2.63674091975e-07, 2.218e-07, 2.62481383966e-07, 2.22e-07, 2.61293066961e-07, 2.222e-07, 2.60109982469e-07, 2.224e-07, 2.58932933718e-07, 2.226e-07, 2.5776268594e-07, 2.228e-07, 2.56599966742e-07, 2.23e-07, 2.55445466559e-07, 2.232e-07, 2.54299839163e-07, 2.234e-07, 2.53163702235e-07, 2.236e-07, 2.52037637993e-07, 2.238e-07, 2.50922193863e-07, 2.24e-07, 2.49817883191e-07, 2.242e-07, 2.48725185988e-07, 2.244e-07, 2.47644549707e-07, 2.246e-07, 2.46576390041e-07, 2.248e-07, 2.45521091742e-07, 2.25e-07, 2.44479009453e-07, 2.252e-07, 2.43450468549e-07, 2.254e-07, 2.4243576599e-07, 2.256e-07, 2.41435171174e-07, 2.258e-07, 2.40448926783e-07, 2.26e-07, 2.39477249643e-07, 2.262e-07, 2.38520331558e-07, 2.264e-07, 2.37578340156e-07, 2.266e-07, 2.36651419708e-07, 2.268e-07, 2.35739691946e-07, 2.27e-07, 2.34843256866e-07, 2.272e-07, 2.33962193512e-07, 2.274e-07, 2.33096560749e-07, 2.276e-07, 2.3224639802e-07, 2.278e-07, 2.31411726075e-07, 2.28e-07, 2.305925477e-07, 2.282e-07, 2.29788848409e-07, 2.284e-07, 2.29000597131e-07, 2.286e-07, 2.2822774687e-07, 2.288e-07, 2.27470235348e-07, 2.29e-07, 2.2672798563e-07, 2.292e-07, 2.26000906728e-07, 2.294e-07, 2.25288894192e-07, 2.296e-07, 2.24591830674e-07, 2.298e-07, 2.2390958648e-07, 2.3e-07, 2.23242020104e-07, 2.302e-07, 2.22588978746e-07, 2.304e-07, 2.21950298808e-07, 2.306e-07, 2.21325806383e-07, 2.308e-07, 2.20715317724e-07, 2.31e-07, 2.20118639698e-07, 2.312e-07, 2.19535570229e-07, 2.314e-07, 2.18965898728e-07, 2.316e-07, 2.1840940651e-07, 2.318e-07, 2.17865867203e-07, 2.32e-07, 2.17335047139e-07, 2.322e-07, 2.16816705746e-07, 2.324e-07, 2.16310595923e-07, 2.326e-07, 2.15816464409e-07, 2.328e-07, 2.15334052149e-07, 2.33e-07, 2.14863094648e-07, 2.332e-07, 2.14403322321e-07, 2.334e-07, 2.13954460841e-07, 2.336e-07, 2.13516231479e-07, 2.338e-07, 2.13088351442e-07, 2.34e-07, 2.12670534209e-07, 2.342e-07, 2.12262489861e-07, 2.344e-07, 2.11863925417e-07, 2.346e-07, 2.11474545157e-07, 2.348e-07, 2.11094050957e-07, 2.35e-07, 2.10722142618e-07, 2.352e-07, 2.10358518189e-07, 2.354e-07, 2.10002874306e-07, 2.356e-07, 2.09654906515e-07, 2.358e-07, 2.09314309609e-07, 2.36e-07, 2.0898077796e-07, 2.362e-07, 2.08654005857e-07, 2.364e-07, 2.08333687838e-07, 2.366e-07, 2.08019519033e-07, 2.368e-07, 2.07711195507e-07, 2.37e-07, 2.07408414598e-07, 2.372e-07, 2.07110875265e-07, 2.374e-07, 2.06818278436e-07, 2.376e-07, 2.06530327354e-07, 2.378e-07, 2.06246727924e-07, 2.38e-07, 2.05967189071e-07, 2.382e-07, 2.05691423084e-07, 2.384e-07, 2.05419145969e-07, 2.386e-07, 2.05150077804e-07, 2.388e-07, 2.04883943085e-07, 2.39e-07, 2.04620471077e-07, 2.392e-07, 2.04359396161e-07, 2.394e-07, 2.0410045818e-07, 2.396e-07, 2.03843402779e-07, 2.398e-07, 2.03587981746e-07, 2.4e-07, 2.03333953342e-07, 2.402e-07, 2.03081082631e-07, 2.404e-07, 2.02829141804e-07, 2.406e-07, 2.02577910491e-07, 2.408e-07, 2.0232717607e-07, 2.41e-07, 2.02076733967e-07, 2.412e-07, 2.01826387946e-07, 2.414e-07, 2.01575950387e-07, 2.416e-07, 2.01325242556e-07, 2.418e-07, 2.01074094864e-07, 2.42e-07, 2.00822347108e-07, 2.422e-07, 2.00569848704e-07, 2.424e-07, 2.00316458906e-07, 2.426e-07, 2.00062047005e-07, 2.428e-07, 1.9980649252e-07, 2.43e-07, 1.99549685366e-07, 2.432e-07, 1.99291526011e-07, 2.434e-07, 1.99031925611e-07, 2.436e-07, 1.98770806132e-07, 2.438e-07, 1.98508100449e-07, 2.44e-07, 1.9824375243e-07, 2.442e-07, 1.97977717004e-07, 2.444e-07, 1.977099602e-07, 2.446e-07, 1.97440459177e-07, 2.448e-07, 1.97169202232e-07, 2.45e-07, 1.96896188784e-07, 2.452e-07, 1.96621429346e-07, 2.454e-07, 1.96344945472e-07, 2.456e-07, 1.96066769688e-07, 2.458e-07, 1.95786945403e-07, 2.46e-07, 1.95505526804e-07, 2.462e-07, 1.9522257873e-07, 2.464e-07, 1.94938176527e-07, 2.466e-07, 1.94652405894e-07, 2.468e-07, 1.94365362706e-07, 2.47e-07, 1.94077152817e-07, 2.472e-07, 1.93787891862e-07, 2.474e-07, 1.93497705031e-07, 2.476e-07, 1.93206726833e-07, 2.478e-07, 1.92915100855e-07, 2.48e-07, 1.92622979499e-07, 2.482e-07, 1.92330523714e-07, 2.484e-07, 1.92037902714e-07, 2.486e-07, 1.91745293692e-07, 2.488e-07, 1.91452881525e-07, 2.49e-07, 1.91160858463e-07, 2.492e-07, 1.90869423831e-07, 2.494e-07, 1.90578783702e-07, 2.496e-07, 1.90289150588e-07, 2.498e-07, 1.90000743113e-07, 2.5e-07, 1.89713785693e-07, 2.502e-07, 1.89428508208e-07, 2.504e-07, 1.89145145677e-07, 2.506e-07, 1.88863937938e-07, 2.508e-07, 1.88585129322e-07, 2.51e-07, 1.88308968334e-07, 2.512e-07, 1.88035707336e-07, 2.514e-07, 1.87765602237e-07, 2.516e-07, 1.87498912182e-07, 2.518e-07, 1.87235899251e-07, 2.52e-07, 1.86976828166e-07, 2.522e-07, 1.86721965998e-07, 2.524e-07, 1.86471581889e-07, 2.526e-07, 1.86225946777e-07, 2.528e-07, 1.85985333129e-07, 2.53e-07, 1.85750014687e-07, 2.532e-07, 1.8552026622e-07, 2.534e-07, 1.85296363287e-07, 2.536e-07, 1.85078582005e-07, 2.538e-07, 1.84867198836e-07, 2.54e-07, 1.84662490374e-07, 2.542e-07, 1.84464733152e-07, 2.544e-07, 1.84274203447e-07, 2.546e-07, 1.84091177112e-07, 2.548e-07, 1.839159294e-07, 2.55e-07, 1.8374873481e-07, 2.552e-07, 1.83589866943e-07, 2.554e-07, 1.83439598361e-07, 2.556e-07, 1.83298200461e-07, 2.558e-07, 1.83165943356e-07, 2.56e-07, 1.83043095769e-07, 2.562e-07, 1.82929924931e-07, 2.564e-07, 1.82826696493e-07, 2.566e-07, 1.82733674438e-07, 2.568e-07, 1.82651121013e-07, 2.57e-07, 1.82579296658e-07, 2.572e-07, 1.82518459947e-07, 2.574e-07, 1.82468867534e-07, 2.576e-07, 1.82430774109e-07, 2.578e-07, 1.82404432354e-07, 2.58e-07, 1.82390092908e-07, 2.582e-07, 1.82388004337e-07, 2.584e-07, 1.82398413106e-07, 2.586e-07, 1.82421563558e-07, 2.588e-07, 1.82457697892e-07, 2.59e-07, 1.82507056148e-07, 2.592e-07, 1.8256987619e-07, 2.594e-07, 1.82646393693e-07, 2.596e-07, 1.82736842134e-07, 2.598e-07, 1.82841452774e-07, 2.6e-07, 1.82960454649e-07, 2.602e-07, 1.83094074557e-07, 2.604e-07, 1.83242537042e-07, 2.606e-07, 1.83406064377e-07, 2.608e-07, 1.83584876543e-07, 2.61e-07, 1.83779191212e-07, 2.612e-07, 1.83989223713e-07, 2.614e-07, 1.84215187003e-07, 2.616e-07, 1.84457291632e-07, 2.618e-07, 1.84715745696e-07, 2.62e-07, 1.84990754794e-07, 2.622e-07, 1.85282521965e-07, 2.624e-07, 1.85591247625e-07, 2.626e-07, 1.85917129498e-07, 2.628e-07, 1.86260362527e-07, 2.63e-07, 1.86621138786e-07, 2.632e-07, 1.86999647376e-07, 2.634e-07, 1.87396074308e-07, 2.636e-07, 1.87810602382e-07, 2.638e-07, 1.88243411038e-07, 2.64e-07, 1.88694676213e-07, 2.642e-07, 1.89164570168e-07, 2.644e-07, 1.89653261305e-07, 2.646e-07, 1.90160913972e-07, 2.648e-07, 1.90687688246e-07, 2.65e-07, 1.91233739704e-07, 2.652e-07, 1.91799219169e-07, 2.654e-07, 1.92384272444e-07, 2.656e-07, 1.92989040027e-07, 2.658e-07, 1.93613656794e-07, 2.66e-07, 1.94258251682e-07, 2.662e-07, 1.94922947328e-07, 2.664e-07, 1.95607859703e-07, 2.666e-07, 1.96313097713e-07, 2.668e-07, 1.97038762779e-07, 2.67e-07, 1.977849484e-07, 2.672e-07, 1.98551739674e-07, 2.674e-07, 1.99339212814e-07, 2.676e-07, 2.00147434625e-07, 2.678e-07, 2.00976461955e-07, 2.68e-07, 2.0182634113e-07, 2.682e-07, 2.02697107346e-07, 2.684e-07, 2.03588784048e-07, 2.686e-07, 2.04501382274e-07, 2.688e-07, 2.05434899973e-07, 2.69e-07, 2.06389321294e-07, 2.692e-07, 2.07364615851e-07, 2.694e-07, 2.0836073796e-07, 2.696e-07, 2.09377625843e-07, 2.698e-07, 2.10415200815e-07, 2.7e-07, 2.11473366441e-07, 2.702e-07, 2.12552007664e-07, 2.704e-07, 2.13650989919e-07, 2.706e-07, 2.14770158215e-07, 2.708e-07, 2.15909336202e-07, 2.71e-07, 2.17068325217e-07, 2.712e-07, 2.1824690331e-07, 2.714e-07, 2.19444824261e-07, 2.716e-07, 2.20661816577e-07, 2.718e-07, 2.21897582487e-07, 2.72e-07, 2.23151796922e-07, 2.722e-07, 2.24424106499e-07, 2.724e-07, 2.25714128501e-07, 2.726e-07, 2.27021449863e-07, 2.728e-07, 2.28345626168e-07, 2.73e-07, 2.29686180654e-07, 2.732e-07, 2.31042603245e-07, 2.734e-07, 2.32414349599e-07, 2.736e-07, 2.33800840196e-07, 2.738e-07, 2.35201459456e-07, 2.74e-07, 2.36615554902e-07, 2.742e-07, 2.38042436377e-07, 2.744e-07, 2.39481375313e-07, 2.746e-07, 2.40931604076e-07, 2.748e-07, 2.4239231537e-07, 2.75e-07, 2.43862661741e-07, 2.752e-07, 2.45341755154e-07, 2.754e-07, 2.46828666689e-07, 2.756e-07, 2.48322426324e-07, 2.758e-07, 2.49822022857e-07, 2.76e-07, 2.51326403939e-07, 2.762e-07, 2.5283447625e-07, 2.764e-07, 2.54345105822e-07, 2.766e-07, 2.55857118508e-07, 2.768e-07, 2.57369300622e-07, 2.77e-07, 2.58880399746e-07, 2.772e-07, 2.60389125709e-07, 2.774e-07, 2.61894151768e-07, 2.776e-07, 2.63394115962e-07, 2.778e-07, 2.64887622677e-07, 2.78e-07, 2.66373244409e-07, 2.782e-07, 2.67849523734e-07, 2.784e-07, 2.69314975489e-07, 2.786e-07, 2.70768089161e-07, 2.788e-07, 2.72207331491e-07, 2.79e-07, 2.73631149286e-07, 2.792e-07, 2.75037972437e-07, 2.794e-07, 2.76426217141e-07, 2.796e-07, 2.77794289324e-07, 2.798e-07, 2.79140588244e-07, 2.8e-07, 2.80463510281e-07, 2.802e-07, 2.81761452891e-07, 2.804e-07, 2.83032818715e-07, 2.806e-07, 2.84276019832e-07, 2.808e-07, 2.85489482122e-07, 2.81e-07, 2.86671649748e-07, 2.812e-07, 2.87820989713e-07, 2.814e-07, 2.88935996474e-07, 2.816e-07, 2.90015196605e-07, 2.818e-07, 2.91057153467e-07, 2.82e-07, 2.92060471863e-07, 2.822e-07, 2.9302380266e-07, 2.824e-07, 2.93945847342e-07, 2.826e-07, 2.94825362468e-07, 2.828e-07, 2.9566116401e-07, 2.83e-07, 2.96452131537e-07, 2.832e-07, 2.97197212231e-07, 2.834e-07, 2.97895424686e-07, 2.836e-07, 2.98545862487e-07, 2.838e-07, 2.99147697533e-07, 2.84e-07, 2.99700183073e-07, 2.842e-07, 3.00202656456e-07, 2.844e-07, 3.00654541551e-07, 2.846e-07, 3.01055350833e-07, 2.848e-07, 3.01404687122e-07, 2.85e-07, 3.01702244955e-07, 2.852e-07, 3.0194781158e-07, 2.854e-07, 3.02141267577e-07, 2.856e-07, 3.02282587092e-07, 2.858e-07, 3.02371837684e-07, 2.86e-07, 3.0240917979e-07, 2.862e-07, 3.02394865811e-07, 2.864e-07, 3.02329238829e-07, 2.866e-07, 3.02212730965e-07, 2.868e-07, 3.02045861382e-07, 2.87e-07, 3.01829233968e-07, 2.872e-07, 3.01563534697e-07, 2.874e-07, 3.01249528703e-07, 2.876e-07, 3.00888057075e-07, 2.878e-07, 3.00480033408e-07, 2.88e-07, 3.00026440132e-07, 2.882e-07, 2.99528324636e-07, 2.884e-07, 2.98986795229e-07, 2.886e-07, 2.98403016945e-07, 2.888e-07, 2.97778207241e-07, 2.89e-07, 2.97113631597e-07, 2.892e-07, 2.96410599053e-07, 2.894e-07, 2.95670457711e-07, 2.896e-07, 2.94894590218e-07, 2.898e-07, 2.9408440927e-07, 2.9e-07, 2.9324135314e-07, 2.902e-07, 2.92366881273e-07, 2.904e-07, 2.91462469953e-07, 2.906e-07, 2.90529608069e-07, 2.908e-07, 2.89569792992e-07, 2.91e-07, 2.88584526589e-07, 2.912e-07, 2.87575311372e-07, 2.914e-07, 2.86543646812e-07, 2.916e-07, 2.85491025813e-07, 2.918e-07, 2.84418931366e-07, 2.92e-07, 2.83328833387e-07, 2.922e-07, 2.82222185735e-07, 2.924e-07, 2.81100423439e-07, 2.926e-07, 2.79964960098e-07, 2.928e-07, 2.788171855e-07, 2.93e-07, 2.77658463419e-07, 2.932e-07, 2.76490129614e-07, 2.934e-07, 2.75313490022e-07, 2.936e-07, 2.74129819134e-07, 2.938e-07, 2.72940358559e-07, 2.94e-07, 2.71746315763e-07, 2.942e-07, 2.70548862981e-07, 2.944e-07, 2.69349136303e-07, 2.946e-07, 2.68148234904e-07, 2.948e-07, 2.66947220439e-07, 2.95e-07, 2.65747116578e-07, 2.952e-07, 2.64548908671e-07, 2.954e-07, 2.63353543549e-07, 2.956e-07, 2.6216192944e-07, 2.958e-07, 2.60974935999e-07, 2.96e-07, 2.59793394437e-07, 2.962e-07, 2.58618097747e-07, 2.964e-07, 2.57449801024e-07, 2.966e-07, 2.56289221849e-07, 2.968e-07, 2.55137040762e-07, 2.97e-07, 2.53993901789e-07, 2.972e-07, 2.52860413028e-07, 2.974e-07, 2.51737147289e-07, 2.976e-07, 2.50624642779e-07, 2.978e-07, 2.49523403821e-07, 2.98e-07, 2.48433901609e-07, 2.982e-07, 2.4735657499e-07, 2.984e-07, 2.46291831272e-07, 2.986e-07, 2.45240047042e-07, 2.988e-07, 2.44201569002e-07, 2.99e-07, 2.43176714818e-07, 2.992e-07, 2.42165773966e-07, 2.994e-07, 2.41169008588e-07, 2.996e-07, 2.40186654344e-07, 2.998e-07, 2.3921892126e-07, 3e-07, 2.38265994568e-07, 3.002e-07, 2.37328035546e-07, 3.004e-07, 2.36405182334e-07, 3.006e-07, 2.35497550753e-07, 3.008e-07, 2.34605235096e-07, 3.01e-07, 2.33728308917e-07, 3.012e-07, 2.32866825794e-07, 3.014e-07, 2.32020820078e-07, 3.016e-07, 2.31190307631e-07, 3.018e-07, 2.30375286531e-07, 3.02e-07, 2.29575737776e-07, 3.022e-07, 2.28791625955e-07, 3.024e-07, 2.28022899907e-07, 3.026e-07, 2.27269493359e-07, 3.028e-07, 2.26531325546e-07, 3.03e-07, 2.2580830181e-07, 3.032e-07, 2.25100314182e-07, 3.034e-07, 2.24407241946e-07, 3.036e-07, 2.23728952188e-07, 3.038e-07, 2.23065300319e-07, 3.04e-07, 2.22416130591e-07, 3.042e-07, 2.21781276593e-07, 3.044e-07, 2.21160561731e-07, 3.046e-07, 2.20553799694e-07, 3.048e-07, 2.19960794905e-07, 3.05e-07, 2.19381342961e-07, 3.052e-07, 2.18815231061e-07, 3.054e-07, 2.18262238416e-07, 3.056e-07, 2.17722136656e-07, 3.058e-07, 2.17194690223e-07, 3.06e-07, 2.16679656756e-07, 3.062e-07, 2.16176787463e-07, 3.064e-07, 2.15685827495e-07, 3.066e-07, 2.15206516299e-07, 3.068e-07, 2.14738587981e-07, 3.07e-07, 2.14281771649e-07, 3.072e-07, 2.13835791761e-07, 3.074e-07, 2.13400368465e-07, 3.076e-07, 2.12975217933e-07, 3.078e-07, 2.125600527e-07, 3.08e-07, 2.12154581992e-07, 3.082e-07, 2.11758512061e-07, 3.084e-07, 2.11371546509e-07, 3.086e-07, 2.10993386623e-07, 3.088e-07, 2.10623731701e-07, 3.09e-07, 2.10262279381e-07, 3.092e-07, 2.09908725973e-07, 3.094e-07, 2.09562766789e-07, 3.096e-07, 2.09224096475e-07, 3.098e-07, 2.0889240935e-07, 3.1e-07, 2.08567399733e-07, 3.102e-07, 2.0824876229e-07, 3.104e-07, 2.07936192368e-07, 3.106e-07, 2.0762938634e-07, 3.108e-07, 2.07328041946e-07, 3.11e-07, 2.07031858638e-07, 3.112e-07, 2.06740537931e-07, 3.114e-07, 2.06453783749e-07, 3.116e-07, 2.06171302774e-07, 3.118e-07, 2.05892804798e-07, 3.12e-07, 2.05618003074e-07, 3.122e-07, 2.05346614667e-07, 3.124e-07, 2.05078360806e-07, 3.126e-07, 2.04812967234e-07, 3.128e-07, 2.04550164553e-07, 3.13e-07, 2.04289688578e-07, 3.132e-07, 2.04031280676e-07, 3.134e-07, 2.03774688109e-07, 3.136e-07, 2.03519664368e-07, 3.138e-07, 2.03265969509e-07, 3.14e-07, 2.03013370478e-07, 3.142e-07, 2.02761641432e-07, 3.144e-07, 2.02510564051e-07, 3.146e-07, 2.02259927845e-07, 3.148e-07, 2.0200953045e-07, 3.15e-07, 2.01759177915e-07, 3.152e-07, 2.01508684979e-07, 3.154e-07, 2.01257875341e-07, 3.156e-07, 2.01006581904e-07, 3.158e-07, 2.00754647028e-07, 3.16e-07, 2.00501922747e-07, 3.162e-07, 2.00248270992e-07, 3.164e-07, 1.99993563781e-07, 3.166e-07, 1.99737683407e-07, 3.168e-07, 1.99480522605e-07, 3.17e-07, 1.99221984698e-07, 3.172e-07, 1.98961983732e-07, 3.174e-07, 1.98700444594e-07, 3.176e-07, 1.98437303101e-07, 3.178e-07, 1.98172506086e-07, 3.18e-07, 1.97906011453e-07, 3.182e-07, 1.97637788217e-07, 3.184e-07, 1.97367816527e-07, 3.186e-07, 1.97096087668e-07, 3.188e-07, 1.96822604041e-07, 3.19e-07, 1.96547379128e-07, 3.192e-07, 1.96270437436e-07, 3.194e-07, 1.95991814423e-07, 3.196e-07, 1.95711556401e-07, 3.198e-07, 1.95429720429e-07, 3.2e-07, 1.95146374182e-07, 3.202e-07, 1.94861595802e-07, 3.204e-07, 1.94575473737e-07, 3.206e-07, 1.9428810656e-07, 3.208e-07, 1.93999602772e-07, 3.21e-07, 1.93710080595e-07, 3.212e-07, 1.93419667742e-07, 3.214e-07, 1.93128501188e-07, 3.216e-07, 1.92836726908e-07, 3.218e-07, 1.92544499628e-07, 3.22e-07, 1.92251982541e-07, 3.222e-07, 1.91959347034e-07, 3.224e-07, 1.9166677239e-07, 3.226e-07, 1.91374445497e-07, 3.228e-07, 1.91082560534e-07, 3.23e-07, 1.90791318668e-07, 3.232e-07, 1.90500927733e-07, 3.234e-07, 1.90211601912e-07, 3.236e-07, 1.89923561418e-07, 3.238e-07, 1.89637032163e-07, 3.24e-07, 1.89352245439e-07, 3.242e-07, 1.89069437591e-07, 3.244e-07, 1.88788849695e-07, 3.246e-07, 1.88510727233e-07, 3.248e-07, 1.88235319776e-07, 3.25e-07, 1.8796288067e-07, 3.252e-07, 1.87693666721e-07, 3.254e-07, 1.87427937892e-07, 3.256e-07, 1.87165957001e-07, 3.258e-07, 1.86907989429e-07, 3.26e-07, 1.8665430283e-07, 3.262e-07, 1.86405166854e-07, 3.264e-07, 1.86160852875e-07, 3.266e-07, 1.85921633729e-07, 3.268e-07, 1.85687783456e-07, 3.27e-07, 1.8545957706e-07, 3.272e-07, 1.85237290272e-07, 3.274e-07, 1.85021199323e-07, 3.276e-07, 1.8481158073e-07, 3.278e-07, 1.8460871109e-07, 3.28e-07, 1.84412866884e-07, 3.282e-07, 1.84224324295e-07, 3.284e-07, 1.84043359028e-07, 3.286e-07, 1.8387024615e-07, 3.288e-07, 1.83705259934e-07, 3.29e-07, 1.83548673713e-07, 3.292e-07, 1.8340075975e-07, 3.294e-07, 1.83261789107e-07, 3.296e-07, 1.83132031535e-07, 3.298e-07, 1.83011755367e-07, 3.3e-07, 1.82901227416e-07, 3.302e-07, 1.82800712895e-07, 3.304e-07, 1.82710475328e-07, 3.306e-07, 1.82630776482e-07, 3.308e-07, 1.82561876302e-07, 3.31e-07, 1.82504032852e-07, 3.312e-07, 1.82457502263e-07, 3.314e-07, 1.82422538689e-07, 3.316e-07, 1.82399394268e-07, 3.318e-07, 1.82388319085e-07, 3.32e-07, 1.82389561145e-07, 3.322e-07, 1.82403366345e-07, 3.324e-07, 1.82429978454e-07, 3.326e-07, 1.82469639093e-07, 3.328e-07, 1.82522587719e-07, 3.33e-07, 1.82589061611e-07, 3.332e-07, 1.82669295855e-07, 3.334e-07, 1.82763523333e-07, 3.336e-07, 1.8287197471e-07, 3.338e-07, 1.82994878425e-07, 3.34e-07, 1.8313246067e-07, 3.342e-07, 1.83284945381e-07, 3.344e-07, 1.83452554219e-07, 3.346e-07, 1.83635506548e-07, 3.348e-07, 1.83834019413e-07, 3.35e-07, 1.84048307509e-07, 3.352e-07, 1.84278583152e-07, 3.354e-07, 1.84525056238e-07, 3.356e-07, 1.84787934197e-07, 3.358e-07, 1.85067421945e-07, 3.36e-07, 1.85363721827e-07, 3.362e-07, 1.85677033542e-07, 3.364e-07, 1.86007554075e-07, 3.366e-07, 1.86355477611e-07, 3.368e-07, 1.86720995434e-07, 3.37e-07, 1.8710429583e-07, 3.372e-07, 1.87505563959e-07, 3.374e-07, 1.87924981732e-07, 3.376e-07, 1.88362727668e-07, 3.378e-07, 1.88818976732e-07, 3.38e-07, 1.89293900167e-07, 3.382e-07, 1.89787665308e-07, 3.384e-07, 1.90300435378e-07, 3.386e-07, 1.90832369271e-07, 3.388e-07, 1.9138362131e-07, 3.39e-07, 1.91954341001e-07, 3.392e-07, 1.9254467275e-07, 3.394e-07, 1.93154755576e-07, 3.396e-07, 1.93784722797e-07, 3.398e-07, 1.94434701692e-07, 3.4e-07, 1.95104813147e-07, 3.402e-07, 1.95795171275e-07, 3.404e-07, 1.96505883016e-07, 3.406e-07, 1.9723704771e-07, 3.408e-07, 1.97988756645e-07, 3.41e-07, 1.98761092586e-07, 3.412e-07, 1.99554129273e-07, 3.414e-07, 2.0036793089e-07, 3.416e-07, 2.01202551521e-07, 3.418e-07, 2.02058034562e-07, 3.42e-07, 2.02934412118e-07, 3.422e-07, 2.0383170437e-07, 3.424e-07, 2.04749918909e-07, 3.426e-07, 2.05689050051e-07, 3.428e-07, 2.06649078117e-07, 3.43e-07, 2.0762996869e-07, 3.432e-07, 2.08631671845e-07, 3.434e-07, 2.09654121347e-07, 3.436e-07, 2.1069723383e-07, 3.438e-07, 2.11760907946e-07, 3.44e-07, 2.1284502349e-07, 3.442e-07, 2.13949440505e-07, 3.444e-07, 2.15073998359e-07, 3.446e-07, 2.16218514807e-07, 3.448e-07, 2.17382785029e-07, 3.45e-07, 2.1856658066e-07, 3.452e-07, 2.19769648794e-07, 3.454e-07, 2.20991710982e-07, 3.456e-07, 2.22232462226e-07, 3.458e-07, 2.23491569957e-07, 3.46e-07, 2.24768673018e-07, 3.462e-07, 2.26063380643e-07, 3.464e-07, 2.2737527145e-07, 3.466e-07, 2.28703892436e-07, 3.468e-07, 2.30048757992e-07, 3.47e-07, 2.31409348934e-07, 3.472e-07, 2.32785111566e-07, 3.474e-07, 2.34175456774e-07, 3.476e-07, 2.35579759152e-07, 3.478e-07, 2.36997356184e-07, 3.48e-07, 2.3842754747e-07, 3.482e-07, 2.39869594019e-07, 3.484e-07, 2.41322717603e-07, 3.486e-07, 2.42786100193e-07, 3.488e-07, 2.44258883478e-07, 3.49e-07, 2.45740168475e-07, 3.492e-07, 2.47229015245e-07, 3.494e-07, 2.48724442716e-07, 3.496e-07, 2.50225428632e-07, 3.498e-07, 2.51730909621e-07, 3.5e-07, 2.53239781416e-07, 3.502e-07, 2.54750899209e-07, 3.504e-07, 2.56263078171e-07, 3.506e-07, 2.57775094131e-07, 3.508e-07, 2.59285684433e-07, 3.51e-07, 2.60793548967e-07, 3.512e-07, 2.62297351393e-07, 3.514e-07, 2.63795720554e-07, 3.516e-07, 2.65287252096e-07, 3.518e-07, 2.6677051028e-07, 3.52e-07, 2.68244030013e-07, 3.522e-07, 2.69706319084e-07, 3.524e-07, 2.7115586061e-07, 3.526e-07, 2.72591115696e-07, 3.528e-07, 2.74010526303e-07, 3.53e-07, 2.75412518321e-07, 3.532e-07, 2.76795504847e-07, 3.534e-07, 2.78157889654e-07, 3.536e-07, 2.79498070849e-07, 3.538e-07, 2.80814444706e-07, 3.54e-07, 2.82105409664e-07, 3.542e-07, 2.83369370474e-07, 3.544e-07, 2.84604742485e-07, 3.546e-07, 2.85809956043e-07, 3.548e-07, 2.86983460992e-07, 3.55e-07, 2.88123731247e-07, 3.552e-07, 2.8922926943e-07, 3.554e-07, 2.90298611531e-07, 3.556e-07, 2.91330331579e-07, 3.558e-07, 2.92323046291e-07, 3.56e-07, 2.93275419677e-07, 3.562e-07, 2.94186167574e-07, 3.564e-07, 2.95054062067e-07, 3.566e-07, 2.95877935797e-07, 3.568e-07, 2.96656686097e-07, 3.57e-07, 2.97389278953e-07, 3.572e-07, 2.9807475275e-07, 3.574e-07, 2.9871222178e-07, 3.576e-07, 2.99300879492e-07, 3.578e-07, 2.99840001454e-07, 3.58e-07, 3.00328948016e-07, 3.582e-07, 3.00767166641e-07, 3.584e-07, 3.01154193902e-07, 3.586e-07, 3.01489657119e-07, 3.588e-07, 3.01773275632e-07, 3.59e-07, 3.02004861701e-07, 3.592e-07, 3.02184321014e-07, 3.594e-07, 3.02311652823e-07, 3.596e-07, 3.02386949688e-07, 3.598e-07, 3.02410396838e-07, 3.6e-07, 3.02382271156e-07, 3.602e-07, 3.02302939803e-07, 3.604e-07, 3.02172858473e-07, 3.606e-07, 3.01992569315e-07, 3.608e-07, 3.01762698523e-07, 3.61e-07, 3.0148395362e-07, 3.612e-07, 3.01157120454e-07, 3.614e-07, 3.00783059925e-07, 3.616e-07, 3.00362704476e-07, 3.618e-07, 2.99897054362e-07, 3.62e-07, 2.9938717373e-07, 3.622e-07, 2.9883418653e-07, 3.624e-07, 2.98239272298e-07, 3.626e-07, 2.97603661816e-07, 3.628e-07, 2.96928632697e-07, 3.63e-07, 2.96215504909e-07, 3.632e-07, 2.95465636272e-07, 3.634e-07, 2.9468041794e-07, 3.636e-07, 2.93861269909e-07, 3.638e-07, 2.93009636569e-07, 3.64e-07, 2.92126982304e-07, 3.642e-07, 2.91214787194e-07, 3.644e-07, 2.90274542804e-07, 3.646e-07, 2.89307748099e-07, 3.648e-07, 2.88315905489e-07, 3.65e-07, 2.87300517026e-07, 3.652e-07, 2.86263080757e-07, 3.654e-07, 2.85205087246e-07, 3.656e-07, 2.84128016277e-07, 3.658e-07, 2.8303333374e-07, 3.66e-07, 2.81922488706e-07, 3.662e-07, 2.80796910695e-07, 3.664e-07, 2.79658007143e-07, 3.666e-07, 2.7850716106e-07, 3.668e-07, 2.77345728891e-07, 3.67e-07, 2.76175038558e-07, 3.672e-07, 2.74996387708e-07, 3.674e-07, 2.73811042141e-07, 3.676e-07, 2.72620234414e-07, 3.678e-07, 2.71425162637e-07, 3.68e-07, 2.70226989427e-07, 3.682e-07, 2.69026841032e-07, 3.684e-07, 2.67825806608e-07, 3.686e-07, 2.66624937656e-07, 3.688e-07, 2.65425247584e-07, 3.69e-07, 2.64227711417e-07, 3.692e-07, 2.63033265629e-07, 3.694e-07, 2.61842808085e-07, 3.696e-07, 2.60657198103e-07, 3.698e-07, 2.5947725661e-07, 3.7e-07, 2.5830376639e-07, 3.702e-07, 2.57137472427e-07, 3.704e-07, 2.5597908231e-07, 3.706e-07, 2.54829266724e-07, 3.708e-07, 2.53688659988e-07, 3.71e-07, 2.52557860666e-07, 3.712e-07, 2.51437432209e-07, 3.714e-07, 2.50327903655e-07, 3.716e-07, 2.4922977036e-07, 3.718e-07, 2.48143494756e-07, 3.72e-07, 2.47069507146e-07, 3.722e-07, 2.46008206507e-07, 3.724e-07, 2.44959961323e-07, 3.726e-07, 2.43925110419e-07, 3.728e-07, 2.42903963808e-07, 3.73e-07, 2.41896803548e-07, 3.732e-07, 2.40903884586e-07, 3.734e-07, 2.39925435618e-07, 3.736e-07, 2.38961659932e-07, 3.738e-07, 2.3801273625e-07, 3.74e-07, 2.37078819557e-07, 3.742e-07, 2.36160041923e-07, 3.744e-07, 2.35256513313e-07, 3.746e-07, 2.34368322376e-07, 3.748e-07, 2.33495537229e-07, 3.75e-07, 2.32638206215e-07, 3.752e-07, 2.31796358653e-07, 3.754e-07, 2.3097000556e-07, 3.756e-07, 2.30159140362e-07, 3.758e-07, 2.29363739588e-07, 3.76e-07, 2.28583763533e-07, 3.762e-07, 2.27819156919e-07, 3.764e-07, 2.27069849523e-07, 3.766e-07, 2.26335756792e-07, 3.768e-07, 2.25616780437e-07, 3.77e-07, 2.24912809015e-07, 3.772e-07, 2.24223718482e-07, 3.774e-07, 2.23549372738e-07, 3.776e-07, 2.2288962415e-07, 3.778e-07, 2.22244314059e-07, 3.78e-07, 2.21613273273e-07, 3.782e-07, 2.20996322546e-07, 3.784e-07, 2.20393273035e-07, 3.786e-07, 2.19803926752e-07, 3.788e-07, 2.19228076998e-07, 3.79e-07, 2.18665508786e-07, 3.792e-07, 2.18115999255e-07, 3.794e-07, 2.17579318066e-07, 3.796e-07, 2.17055227799e-07, 3.798e-07, 2.16543484328e-07, 3.8e-07, 2.160438372e-07, 3.802e-07, 2.15556029999e-07, 3.804e-07, 2.15079800706e-07, 3.806e-07, 2.14614882049e-07, 3.808e-07, 2.14161001856e-07, 3.81e-07, 2.13717883393e-07, 3.812e-07, 2.13285245708e-07, 3.814e-07, 2.12862803965e-07, 3.816e-07, 2.12450269777e-07, 3.818e-07, 2.12047351541e-07, 3.82e-07, 2.11653754763e-07, 3.822e-07, 2.11269182393e-07, 3.824e-07, 2.10893335151e-07, 3.826e-07, 2.10525911857e-07, 3.828e-07, 2.10166609761e-07, 3.83e-07, 2.09815124871e-07, 3.832e-07, 2.09471152288e-07, 3.834e-07, 2.09134386538e-07, 3.836e-07, 2.08804521906e-07, 3.838e-07, 2.08481252772e-07, 3.84e-07, 2.08164273951e-07, 3.842e-07, 2.07853281032e-07, 3.844e-07, 2.0754797072e-07, 3.846e-07, 2.07248041181e-07, 3.848e-07, 2.06953192387e-07, 3.85e-07, 2.06663126466e-07, 3.852e-07, 2.06377548047e-07, 3.854e-07, 2.06096164613e-07, 3.856e-07, 2.05818686849e-07, 3.858e-07, 2.05544828999e-07, 3.86e-07, 2.0527430921e-07, 3.862e-07, 2.05006849889e-07, 3.864e-07, 2.04742178048e-07, 3.866e-07, 2.04480025656e-07, 3.868e-07, 2.04220129984e-07, 3.87e-07, 2.03962233948e-07, 3.872e-07, 2.03706086449e-07, 3.874e-07, 2.03451442708e-07, 3.876e-07, 2.03198064599e-07, 3.878e-07, 2.02945720973e-07, 3.88e-07, 2.02694187974e-07, 3.882e-07, 2.02443249357e-07, 3.884e-07, 2.02192696782e-07, 3.886e-07, 2.01942330117e-07, 3.888e-07, 2.01691957716e-07, 3.89e-07, 2.014413967e-07, 3.892e-07, 2.0119047321e-07, 3.894e-07, 2.00939022669e-07, 3.896e-07, 2.00686890009e-07, 3.898e-07, 2.00433929902e-07, 3.9e-07, 2.00180006967e-07, 3.902e-07, 1.99924995963e-07, 3.904e-07, 1.99668781971e-07, 3.906e-07, 1.99411260553e-07, 3.908e-07, 1.99152337899e-07, 3.91e-07, 1.98891930955e-07, 3.912e-07, 1.98629967532e-07, 3.914e-07, 1.98366386398e-07, 3.916e-07, 1.98101137353e-07, 3.918e-07, 1.97834181279e-07, 3.92e-07, 1.97565490181e-07, 3.922e-07, 1.97295047197e-07, 3.924e-07, 1.97022846597e-07, 3.926e-07, 1.96748893763e-07, 3.928e-07, 1.96473205141e-07, 3.93e-07, 1.96195808187e-07, 3.932e-07, 1.95916741282e-07, 3.934e-07, 1.95636053634e-07, 3.936e-07, 1.95353805167e-07, 3.938e-07, 1.9507006638e-07, 3.94e-07, 1.94784918198e-07, 3.942e-07, 1.94498451805e-07, 3.944e-07, 1.94210768458e-07, 3.946e-07, 1.93921979291e-07, 3.948e-07, 1.93632205095e-07, 3.95e-07, 1.93341576094e-07, 3.952e-07, 1.93050231702e-07, 3.954e-07, 1.92758320272e-07, 3.956e-07, 1.92465998827e-07, 3.958e-07, 1.92173432791e-07, 3.96e-07, 1.91880795697e-07, 3.962e-07, 1.915882689e-07, 3.964e-07, 1.91296041275e-07, 3.966e-07, 1.91004308908e-07, 3.968e-07, 1.90713274786e-07, 3.97e-07, 1.9042314848e-07, 3.972e-07, 1.90134145824e-07, 3.974e-07, 1.89846488589e-07, 3.976e-07, 1.89560404167e-07, 3.978e-07, 1.89276125237e-07, 3.98e-07, 1.88993889446e-07, 3.982e-07, 1.88713939084e-07, 3.984e-07, 1.88436520761e-07, 3.986e-07, 1.88161885093e-07, 3.988e-07, 1.87890286385e-07, 3.99e-07, 1.8762198232e-07, 3.992e-07, 1.87357233657e-07, 3.994e-07, 1.87096303931e-07, 3.996e-07, 1.8683945916e-07, 3.998e-07, 1.86586967561e-07, 4e-07, 1.86339099275e-07, 4.002e-07, 1.86096126091e-07, 4.004e-07, 1.85858321195e-07, 4.006e-07, 1.85625958908e-07, 4.008e-07, 1.85399314453e-07, 4.01e-07, 1.85178663716e-07, 4.012e-07, 1.84964283026e-07, 4.014e-07, 1.84756448942e-07, 4.016e-07, 1.84555438047e-07, 4.018e-07, 1.84361526761e-07, 4.02e-07, 1.84174991155e-07, 4.022e-07, 1.83996106778e-07, 4.024e-07, 1.83825148499e-07, 4.026e-07, 1.83662390353e-07, 4.028e-07, 1.83508105397e-07, 4.03e-07, 1.83362565585e-07, 4.032e-07, 1.83226041638e-07, 4.034e-07, 1.83098802936e-07, 4.036e-07, 1.82981117412e-07, 4.038e-07, 1.82873251461e-07, 4.04e-07, 1.82775469846e-07, 4.042e-07, 1.82688035629e-07, 4.044e-07, 1.82611210093e-07, 4.046e-07, 1.82545252684e-07, 4.048e-07, 1.82490420952e-07, 4.05e-07, 1.82446970501e-07, 4.052e-07, 1.82415154947e-07, 4.054e-07, 1.82395225882e-07, 4.056e-07, 1.82387432833e-07, 4.058e-07, 1.82392023242e-07, 4.06e-07, 1.82409242438e-07, 4.062e-07, 1.82439333615e-07, 4.064e-07, 1.82482537814e-07, 4.066e-07, 1.82539093909e-07, 4.068e-07, 1.82609238591e-07, 4.07e-07, 1.82693206356e-07, 4.072e-07, 1.82791229492e-07, 4.074e-07, 1.82903538069e-07, 4.076e-07, 1.83030359921e-07, 4.078e-07, 1.83171920639e-07, 4.08e-07, 1.8332844355e-07, 4.082e-07, 1.83500149699e-07, 4.084e-07, 1.8368725783e-07, 4.086e-07, 1.83889984362e-07, 4.088e-07, 1.84108543353e-07, 4.09e-07, 1.84343146474e-07, 4.092e-07, 1.84594002963e-07, 4.094e-07, 1.84861319582e-07, 4.096e-07, 1.85145300563e-07, 4.098e-07, 1.85446147546e-07, 4.1e-07, 1.8576405951e-07, 4.102e-07, 1.86099232698e-07, 4.104e-07, 1.86451860524e-07, 4.106e-07, 1.8682213348e-07, 4.108e-07, 1.87210239024e-07, 4.11e-07, 1.87616361458e-07, 4.112e-07, 1.88040681797e-07, 4.114e-07, 1.88483377621e-07, 4.116e-07, 1.88944622913e-07, 4.118e-07, 1.89424587888e-07, 4.12e-07, 1.89923438796e-07, 4.122e-07, 1.90441337721e-07, 4.124e-07, 1.90978442353e-07, 4.126e-07, 1.91534905749e-07, 4.128e-07, 1.92110876073e-07, 4.13e-07, 1.92706496314e-07, 4.132e-07, 1.93321903994e-07, 4.134e-07, 1.93957230841e-07, 4.136e-07, 1.94612602456e-07, 4.138e-07, 1.95288137944e-07, 4.14e-07, 1.95983949534e-07, 4.142e-07, 1.96700142167e-07, 4.144e-07, 1.97436813068e-07, 4.146e-07, 1.98194051286e-07, 4.148e-07, 1.98971937211e-07, 4.15e-07, 1.99770542071e-07, 4.152e-07, 2.00589927396e-07, 4.154e-07, 2.01430144457e-07, 4.156e-07, 2.02291233681e-07, 4.158e-07, 2.03173224036e-07, 4.16e-07, 2.04076132388e-07, 4.162e-07, 2.04999962834e-07, 4.164e-07, 2.05944706005e-07, 4.166e-07, 2.06910338341e-07, 4.168e-07, 2.07896821337e-07, 4.17e-07, 2.0890410077e-07, 4.172e-07, 2.09932105889e-07, 4.174e-07, 2.10980748584e-07, 4.176e-07, 2.12049922534e-07, 4.178e-07, 2.13139502319e-07, 4.18e-07, 2.14249342525e-07, 4.182e-07, 2.15379276809e-07, 4.184e-07, 2.16529116964e-07, 4.186e-07, 2.17698651944e-07, 4.188e-07, 2.18887646895e-07, 4.19e-07, 2.20095842152e-07, 4.192e-07, 2.2132295224e-07, 4.194e-07, 2.2256866486e-07, 4.196e-07, 2.23832639869e-07, 4.198e-07, 2.2511450826e-07, 4.2e-07, 2.2641387115e-07, 4.202e-07, 2.27730298765e-07, 4.204e-07, 2.29063329446e-07, 4.206e-07, 2.30412468665e-07, 4.208e-07, 2.31777188065e-07, 4.21e-07, 2.3315692453e-07, 4.212e-07, 2.34551079287e-07, 4.214e-07, 2.35959017047e-07, 4.216e-07, 2.373800652e-07, 4.218e-07, 2.38813513051e-07, 4.22e-07, 2.40258611138e-07, 4.222e-07, 2.41714570601e-07, 4.224e-07, 2.4318056264e-07, 4.226e-07, 2.44655718062e-07, 4.228e-07, 2.46139126913e-07, 4.23e-07, 2.47629838224e-07, 4.232e-07, 2.49126859869e-07, 4.234e-07, 2.50629158541e-07, 4.236e-07, 2.52135659865e-07, 4.238e-07, 2.53645248647e-07, 4.24e-07, 2.55156769281e-07, 4.242e-07, 2.56669026302e-07, 4.244e-07, 2.58180785118e-07, 4.246e-07, 2.59690772908e-07, 4.248e-07, 2.61197679711e-07, 4.25e-07, 2.62700159691e-07, 4.252e-07, 2.64196832615e-07, 4.254e-07, 2.65686285516e-07, 4.256e-07, 2.67167074568e-07, 4.258e-07, 2.68637727169e-07, 4.26e-07, 2.70096744238e-07, 4.262e-07, 2.71542602712e-07, 4.264e-07, 2.72973758266e-07, 4.266e-07, 2.74388648239e-07, 4.268e-07, 2.75785694755e-07, 4.27e-07, 2.77163308061e-07, 4.272e-07, 2.78519890041e-07, 4.274e-07, 2.79853837928e-07, 4.276e-07, 2.81163548177e-07, 4.278e-07, 2.82447420507e-07, 4.28e-07, 2.83703862091e-07, 4.282e-07, 2.84931291866e-07, 4.284e-07, 2.86128144965e-07, 4.286e-07, 2.87292877243e-07, 4.288e-07, 2.88423969865e-07, 4.29e-07, 2.8951993395e-07, 4.292e-07, 2.90579315242e-07, 4.294e-07, 2.91600698773e-07, 4.296e-07, 2.92582713506e-07, 4.298e-07, 2.93524036924e-07, 4.3e-07, 2.94423399529e-07, 4.302e-07, 2.95279589249e-07, 4.304e-07, 2.96091455689e-07, 4.306e-07, 2.96857914232e-07, 4.308e-07, 2.97577949939e-07, 4.31e-07, 2.98250621237e-07, 4.312e-07, 2.9887506336e-07, 4.314e-07, 2.99450491521e-07, 4.316e-07, 2.999762038e-07, 4.318e-07, 3.00451583715e-07, 4.32e-07, 3.00876102468e-07, 4.322e-07, 3.01249320846e-07, 4.324e-07, 3.01570890761e-07, 4.326e-07, 3.01840556425e-07, 4.328e-07, 3.02058155141e-07, 4.33e-07, 3.02223617717e-07, 4.332e-07, 3.02336968494e-07, 4.334e-07, 3.02398324985e-07, 4.336e-07, 3.02407897137e-07, 4.338e-07, 3.0236598622e-07, 4.34e-07, 3.02272983343e-07, 4.342e-07, 3.02129367627e-07, 4.344e-07, 3.01935704032e-07, 4.346e-07, 3.01692640861e-07, 4.348e-07, 3.01400906971e-07, 4.35e-07, 3.01061308687e-07, 4.352e-07, 3.00674726468e-07, 4.354e-07, 3.00242111336e-07, 4.356e-07, 2.99764481088e-07, 4.358e-07, 2.99242916332e-07, 4.36e-07, 2.98678556359e-07, 4.362e-07, 2.98072594891e-07, 4.364e-07, 2.97426275718e-07, 4.366e-07, 2.96740888264e-07, 4.368e-07, 2.960177631e-07, 4.37e-07, 2.95258267438e-07, 4.372e-07, 2.94463800613e-07, 4.374e-07, 2.93635789605e-07, 4.376e-07, 2.92775684598e-07, 4.378e-07, 2.91884954611e-07, 4.38e-07, 2.90965083213e-07, 4.382e-07, 2.90017564353e-07, 4.384e-07, 2.89043898301e-07, 4.386e-07, 2.88045587739e-07, 4.388e-07, 2.87024133996e-07, 4.39e-07, 2.85981033444e-07, 4.392e-07, 2.84917774069e-07, 4.394e-07, 2.83835832224e-07, 4.396e-07, 2.82736669563e-07, 4.398e-07, 2.81621730168e-07, 4.4e-07, 2.80492437873e-07, 4.402e-07, 2.79350193778e-07, 4.404e-07, 2.78196373965e-07, 4.406e-07, 2.77032327405e-07, 4.408e-07, 2.75859374059e-07, 4.41e-07, 2.74678803171e-07, 4.412e-07, 2.73491871746e-07, 4.414e-07, 2.72299803207e-07, 4.416e-07, 2.71103786231e-07, 4.418e-07, 2.69904973752e-07, 4.42e-07, 2.68704482125e-07, 4.422e-07, 2.67503390449e-07, 4.424e-07, 2.66302740034e-07, 4.426e-07, 2.65103534011e-07, 4.428e-07, 2.63906737066e-07, 4.43e-07, 2.6271327531e-07, 4.432e-07, 2.61524036251e-07, 4.434e-07, 2.60339868881e-07, 4.436e-07, 2.59161583861e-07, 4.438e-07, 2.57989953791e-07, 4.44e-07, 2.56825713572e-07, 4.442e-07, 2.55669560839e-07, 4.444e-07, 2.54522156458e-07, 4.446e-07, 2.53384125088e-07, 4.448e-07, 2.52256055802e-07, 4.45e-07, 2.51138502744e-07, 4.452e-07, 2.50031985836e-07, 4.454e-07, 2.48936991521e-07, 4.456e-07, 2.47853973529e-07, 4.458e-07, 2.46783353671e-07, 4.46e-07, 2.4572552266e-07, 4.462e-07, 2.44680840933e-07, 4.464e-07, 2.43649639498e-07, 4.466e-07, 2.42632220781e-07, 4.468e-07, 2.41628859478e-07, 4.47e-07, 2.40639803406e-07, 4.472e-07, 2.39665274359e-07, 4.474e-07, 2.38705468946e-07, 4.476e-07, 2.37760559437e-07, 4.478e-07, 2.36830694585e-07, 4.48e-07, 2.35916000449e-07, 4.482e-07, 2.35016581193e-07, 4.484e-07, 2.34132519879e-07, 4.486e-07, 2.33263879243e-07, 4.488e-07, 2.32410702449e-07, 4.49e-07, 2.3157301383e-07, 4.492e-07, 2.30750819613e-07, 4.494e-07, 2.29944108623e-07, 4.496e-07, 2.29152852964e-07, 4.498e-07, 2.28377008689e-07, 4.5e-07, 2.27616516446e-07, 4.502e-07, 2.26871302105e-07, 4.504e-07, 2.26141277369e-07, 4.506e-07, 2.25426340363e-07, 4.508e-07, 2.24726376206e-07, 4.51e-07, 2.24041257565e-07, 4.512e-07, 2.23370845195e-07, 4.514e-07, 2.22714988451e-07, 4.516e-07, 2.22073525803e-07, 4.518e-07, 2.21446285311e-07, 4.52e-07, 2.20833085109e-07, 4.522e-07, 2.20233733855e-07, 4.524e-07, 2.19648031181e-07, 4.526e-07, 2.19075768122e-07, 4.528e-07, 2.18516727538e-07, 4.53e-07, 2.17970684521e-07, 4.532e-07, 2.17437406794e-07, 4.534e-07, 2.16916655097e-07, 4.536e-07, 2.16408183573e-07, 4.538e-07, 2.15911740131e-07, 4.54e-07, 2.15427066816e-07, 4.542e-07, 2.14953900164e-07, 4.544e-07, 2.14491971555e-07, 4.546e-07, 2.14041007557e-07, 4.548e-07, 2.13600730272e-07, 4.55e-07, 2.13170857672e-07, 4.552e-07, 2.12751103935e-07, 4.554e-07, 2.12341179779e-07, 4.556e-07, 2.11940792791e-07, 4.558e-07, 2.1154964776e-07, 4.56e-07, 2.11167447004e-07, 4.562e-07, 2.10793890702e-07, 4.564e-07, 2.10428677219e-07, 4.566e-07, 2.10071503439e-07, 4.568e-07, 2.09722065094e-07, 4.57e-07, 2.093800571e-07, 4.572e-07, 2.09045173882e-07, 4.574e-07, 2.0871710972e-07, 4.576e-07, 2.08395559076e-07, 4.578e-07, 2.0808021694e-07, 4.58e-07, 2.07770779166e-07, 4.582e-07, 2.07466942818e-07, 4.584e-07, 2.07168406513e-07, 4.586e-07, 2.06874870768e-07, 4.588e-07, 2.06586038347e-07, 4.59e-07, 2.0630161461e-07, 4.592e-07, 2.06021307867e-07, 4.594e-07, 2.05744829723e-07, 4.596e-07, 2.05471895435e-07, 4.598e-07, 2.05202224259e-07, 4.6e-07, 2.04935539804e-07, 4.602e-07, 2.0467157038e-07, 4.604e-07, 2.04410049343e-07, 4.606e-07, 2.04150715447e-07, 4.608e-07, 2.03893313181e-07, 4.61e-07, 2.03637593109e-07, 4.612e-07, 2.03383312208e-07, 4.614e-07, 2.03130234192e-07, 4.616e-07, 2.02878129837e-07, 4.618e-07, 2.02626777303e-07, 4.62e-07, 2.02375962434e-07, 4.622e-07, 2.02125479068e-07, 4.624e-07, 2.01875129321e-07, 4.626e-07, 2.01624723877e-07, 4.628e-07, 2.01374082249e-07, 4.63e-07, 2.01123033049e-07, 4.632e-07, 2.00871414227e-07, 4.634e-07, 2.00619073311e-07, 4.636e-07, 2.00365867621e-07, 4.638e-07, 2.0011166448e-07, 4.64e-07, 1.99856341402e-07, 4.642e-07, 1.99599786264e-07, 4.644e-07, 1.9934189747e-07, 4.646e-07, 1.99082584084e-07, 4.648e-07, 1.98821765959e-07, 4.65e-07, 1.98559373839e-07, 4.652e-07, 1.98295349446e-07, 4.654e-07, 1.98029645552e-07, 4.656e-07, 1.97762226021e-07, 4.658e-07, 1.97493065846e-07, 4.66e-07, 1.97222151154e-07, 4.662e-07, 1.96949479202e-07, 4.664e-07, 1.96675058346e-07, 4.666e-07, 1.96398907994e-07, 4.668e-07, 1.96121058544e-07, 4.67e-07, 1.95841551293e-07, 4.672e-07, 1.9556043834e-07, 4.674e-07, 1.95277782458e-07, 4.676e-07, 1.94993656962e-07, 4.678e-07, 1.94708145549e-07, 4.68e-07, 1.94421342125e-07, 4.682e-07, 1.94133350619e-07, 4.684e-07, 1.93844284778e-07, 4.686e-07, 1.93554267948e-07, 4.688e-07, 1.93263432845e-07, 4.69e-07, 1.92971921308e-07, 4.692e-07, 1.92679884043e-07, 4.694e-07, 1.92387480357e-07, 4.696e-07, 1.92094877877e-07, 4.698e-07, 1.91802252266e-07, 4.7e-07, 1.91509786927e-07, 4.702e-07, 1.91217672702e-07, 4.704e-07, 1.90926107559e-07, 4.706e-07, 1.90635296285e-07, 4.708e-07, 1.90345450163e-07, 4.71e-07, 1.90056786652e-07, 4.712e-07, 1.89769529066e-07, 4.714e-07, 1.89483906245e-07, 4.716e-07, 1.89200152235e-07, 4.718e-07, 1.88918505961e-07, 4.72e-07, 1.88639210904e-07, 4.722e-07, 1.88362514781e-07, 4.724e-07, 1.88088669229e-07, 4.726e-07, 1.87817929489e-07, 4.728e-07, 1.87550554099e-07, 4.73e-07, 1.87286804594e-07, 4.732e-07, 1.87026945203e-07, 4.734e-07, 1.86771242562e-07, 4.736e-07, 1.86519965431e-07, 4.738e-07, 1.8627338442e-07, 4.74e-07, 1.86031771719e-07, 4.742e-07, 1.8579540084e-07, 4.744e-07, 1.85564546373e-07, 4.746e-07, 1.8533948374e-07, 4.748e-07, 1.85120488967e-07, 4.75e-07, 1.84907838466e-07, 4.752e-07, 1.84701808821e-07, 4.754e-07, 1.84502676591e-07, 4.756e-07, 1.84310718119e-07, 4.758e-07, 1.84126209352e-07, 4.76e-07, 1.83949425673e-07, 4.762e-07, 1.8378064174e-07, 4.764e-07, 1.8362013134e-07, 4.766e-07, 1.83468167247e-07, 4.768e-07, 1.83325021095e-07, 4.77e-07, 1.83190963255e-07, 4.772e-07, 1.8306626273e-07, 4.774e-07, 1.82951187048e-07, 4.776e-07, 1.82846002173e-07, 4.778e-07, 1.82750972421e-07, 4.78e-07, 1.82666360382e-07, 4.782e-07, 1.82592426852e-07, 4.784e-07, 1.82529430773e-07, 4.786e-07, 1.82477629177e-07, 4.788e-07, 1.82437277139e-07, 4.79e-07, 1.82408627736e-07, 4.792e-07, 1.82391932006e-07, 4.794e-07, 1.82387438922e-07, 4.796e-07, 1.82395395359e-07, 4.798e-07, 1.82416046076e-07, 4.8e-07, 1.82449633689e-07, 4.802e-07, 1.82496398661e-07, 4.804e-07, 1.82556579281e-07, 4.806e-07, 1.8263041165e-07, 4.808e-07, 1.82718129674e-07, 4.81e-07, 1.82819965048e-07, 4.812e-07, 1.8293614724e-07, 4.814e-07, 1.83066903486e-07, 4.816e-07, 1.8321245877e-07, 4.818e-07, 1.83373035808e-07, 4.82e-07, 1.8354885503e-07, 4.822e-07, 1.83740134559e-07, 4.824e-07, 1.83947090182e-07, 4.826e-07, 1.84169935321e-07, 4.828e-07, 1.84408880998e-07, 4.83e-07, 1.8466413579e-07, 4.832e-07, 1.84935905787e-07, 4.834e-07, 1.8522439453e-07, 4.836e-07, 1.85529802952e-07, 4.838e-07, 1.85852329307e-07, 4.84e-07, 1.86192169086e-07, 4.842e-07, 1.8654951493e-07, 4.844e-07, 1.86924556528e-07, 4.846e-07, 1.87317480502e-07, 4.848e-07, 1.87728470285e-07, 4.85e-07, 1.88157705986e-07, 4.852e-07, 1.88605364236e-07, 4.854e-07, 1.89071618023e-07, 4.856e-07, 1.89556636518e-07, 4.858e-07, 1.90060584875e-07, 4.86e-07, 1.90583624018e-07, 4.862e-07, 1.9112591042e-07, 4.864e-07, 1.91687595851e-07, 4.866e-07, 1.92268827112e-07, 4.868e-07, 1.92869745758e-07, 4.87e-07, 1.93490487784e-07, 4.872e-07, 1.94131183311e-07, 4.874e-07, 1.9479195623e-07, 4.876e-07, 1.95472923841e-07, 4.878e-07, 1.96174196457e-07, 4.88e-07, 1.96895876991e-07, 4.882e-07, 1.97638060519e-07, 4.884e-07, 1.98400833814e-07, 4.886e-07, 1.99184274858e-07, 4.888e-07, 1.99988452329e-07, 4.89e-07, 2.00813425059e-07, 4.892e-07, 2.01659241467e-07, 4.894e-07, 2.02525938966e-07, 4.896e-07, 2.03413543338e-07, 4.898e-07, 2.04322068089e-07, 4.9e-07, 2.05251513772e-07, 4.902e-07, 2.06201867279e-07, 4.904e-07, 2.07173101113e-07, 4.906e-07, 2.0816517263e-07, 4.908e-07, 2.09178023247e-07, 4.91e-07, 2.10211577638e-07, 4.912e-07, 2.1126574289e-07, 4.914e-07, 2.12340407641e-07, 4.916e-07, 2.13435441194e-07, 4.918e-07, 2.14550692609e-07, 4.92e-07, 2.15685989768e-07, 4.922e-07, 2.16841138427e-07, 4.924e-07, 2.18015921247e-07, 4.926e-07, 2.19210096812e-07, 4.928e-07, 2.20423398628e-07, 4.93e-07, 2.21655534118e-07, 4.932e-07, 2.2290618361e-07, 4.934e-07, 2.24174999311e-07, 4.936e-07, 2.25461604296e-07, 4.938e-07, 2.26765591487e-07, 4.94e-07, 2.2808652265e-07, 4.942e-07, 2.29423927397e-07, 4.944e-07, 2.30777302211e-07, 4.946e-07, 2.32146109497e-07, 4.948e-07, 2.33529776653e-07, 4.95e-07, 2.34927695186e-07, 4.952e-07, 2.36339219867e-07, 4.954e-07, 2.37763667932e-07, 4.956e-07, 2.39200318347e-07, 4.958e-07, 2.40648411131e-07, 4.96e-07, 2.42107146753e-07, 4.962e-07, 2.43575685611e-07, 4.964e-07, 2.45053147602e-07, 4.966e-07, 2.46538611782e-07, 4.968e-07, 2.48031116144e-07, 4.97e-07, 2.49529657504e-07, 4.972e-07, 2.51033191514e-07, 4.974e-07, 2.5254063281e-07, 4.976e-07, 2.54050855307e-07, 4.978e-07, 2.55562692634e-07, 4.98e-07, 2.57074938747e-07, 4.982e-07, 2.58586348695e-07, 4.984e-07, 2.60095639573e-07, 4.986e-07, 2.61601491657e-07, 4.988e-07, 2.63102549726e-07, 4.99e-07, 2.64597424587e-07, 4.992e-07, 2.66084694795e-07, 4.994e-07, 2.67562908589e-07, 4.996e-07, 2.69030586024e-07, 4.998e-07, 2.70486221325e-07, 5e-07, 2.71928285449e-07, 5.002e-07, 2.73355228853e-07, 5.004e-07, 2.74765484474e-07, 5.006e-07, 2.76157470914e-07, 5.008e-07, 2.77529595822e-07, 5.01e-07, 2.78880259461e-07, 5.012e-07, 2.80207858469e-07, 5.014e-07, 2.81510789772e-07, 5.016e-07, 2.82787454676e-07, 5.018e-07, 2.8403626308e-07, 5.02e-07, 2.85255637831e-07, 5.022e-07, 2.86444019178e-07, 5.024e-07, 2.87599869315e-07, 5.026e-07, 2.88721676991e-07, 5.028e-07, 2.89807962161e-07, 5.03e-07, 2.90857280658e-07, 5.032e-07, 2.91868228852e-07, 5.034e-07, 2.92839448284e-07, 5.036e-07, 2.93769630229e-07, 5.038e-07, 2.9465752018e-07, 5.04e-07, 2.95501922208e-07, 5.042e-07, 2.96301703181e-07, 5.044e-07, 2.97055796811e-07, 5.046e-07, 2.97763207502e-07, 5.048e-07, 2.9842301397e-07, 5.05e-07, 2.99034372619e-07, 5.052e-07, 2.99596520637e-07, 5.054e-07, 3.00108778798e-07, 5.056e-07, 3.00570553951e-07, 5.058e-07, 3.00981341174e-07, 5.06e-07, 3.0134072558e-07, 5.062e-07, 3.01648383758e-07, 5.064e-07, 3.01904084846e-07, 5.066e-07, 3.02107691223e-07, 5.068e-07, 3.02259158818e-07, 5.07e-07, 3.02358537035e-07, 5.072e-07, 3.02405968286e-07, 5.074e-07, 3.02401687159e-07, 5.076e-07, 3.02346019198e-07, 5.078e-07, 3.02239379334e-07, 5.08e-07, 3.02082269956e-07, 5.082e-07, 3.01875278655e-07, 5.084e-07, 3.01619075644e-07, 5.086e-07, 3.01314410887e-07, 5.088e-07, 3.00962110949e-07, 5.09e-07, 3.00563075591e-07, 5.092e-07, 3.00118274138e-07, 5.094e-07, 2.99628741646e-07, 5.096e-07, 2.99095574885e-07, 5.098e-07, 2.98519928181e-07, 5.1e-07, 2.97903009127e-07, 5.102e-07, 2.97246074201e-07, 5.104e-07, 2.96550424316e-07, 5.106e-07, 2.9581740032e-07, 5.108e-07, 2.9504837849e-07, 5.11e-07, 2.94244766023e-07, 5.112e-07, 2.9340799656e-07, 5.114e-07, 2.92539525766e-07, 5.116e-07, 2.91640826983e-07, 5.118e-07, 2.90713386971e-07, 5.12e-07, 2.89758701768e-07, 5.122e-07, 2.88778272671e-07, 5.124e-07, 2.87773602362e-07, 5.126e-07, 2.86746191184e-07, 5.128e-07, 2.85697533588e-07, 5.13e-07, 2.8462911475e-07, 5.132e-07, 2.83542407368e-07, 5.134e-07, 2.82438868655e-07, 5.136e-07, 2.81319937513e-07, 5.138e-07, 2.80187031907e-07, 5.14e-07, 2.79041546439e-07, 5.142e-07, 2.77884850111e-07, 5.144e-07, 2.76718284283e-07, 5.146e-07, 2.75543160833e-07, 5.148e-07, 2.74360760492e-07, 5.15e-07, 2.73172331373e-07, 5.152e-07, 2.71979087682e-07, 5.154e-07, 2.7078220859e-07, 5.156e-07, 2.69582837288e-07, 5.158e-07, 2.6838208019e-07, 5.16e-07, 2.67181006298e-07, 5.162e-07, 2.65980646707e-07, 5.164e-07, 2.64781994247e-07, 5.166e-07, 2.63586003258e-07, 5.168e-07, 2.62393589486e-07, 5.17e-07, 2.61205630087e-07, 5.172e-07, 2.60022963743e-07, 5.174e-07, 2.58846390865e-07, 5.176e-07, 2.57676673898e-07, 5.178e-07, 2.56514537693e-07, 5.18e-07, 2.55360669961e-07, 5.182e-07, 2.54215721793e-07, 5.184e-07, 2.53080308232e-07, 5.186e-07, 2.51955008909e-07, 5.188e-07, 2.5084036871e-07, 5.19e-07, 2.49736898497e-07, 5.192e-07, 2.48645075853e-07, 5.194e-07, 2.47565345862e-07, 5.196e-07, 2.46498121907e-07, 5.198e-07, 2.4544378649e-07, 5.2e-07, 2.44402692067e-07, 5.202e-07, 2.4337516189e-07, 5.204e-07, 2.42361490856e-07, 5.206e-07, 2.41361946363e-07, 5.208e-07, 2.40376769159e-07, 5.21e-07, 2.39406174194e-07, 5.212e-07, 2.38450351462e-07, 5.214e-07, 2.3750946684e-07, 5.216e-07, 2.36583662909e-07, 5.218e-07, 2.35673059772e-07, 5.22e-07, 2.34777755851e-07, 5.222e-07, 2.33897828678e-07, 5.224e-07, 2.33033335659e-07, 5.226e-07, 2.32184314833e-07, 5.228e-07, 2.31350785602e-07, 5.23e-07, 2.30532749453e-07, 5.232e-07, 2.29730190656e-07, 5.234e-07, 2.28943076943e-07, 5.236e-07, 2.28171360167e-07, 5.238e-07, 2.27414976949e-07, 5.24e-07, 2.26673849298e-07, 5.242e-07, 2.25947885214e-07, 5.244e-07, 2.25236979275e-07, 5.246e-07, 2.24541013204e-07, 5.248e-07, 2.23859856419e-07, 5.25e-07, 2.23193366564e-07, 5.252e-07, 2.22541390023e-07, 5.254e-07, 2.21903762425e-07, 5.256e-07, 2.2128030912e-07, 5.258e-07, 2.20670845652e-07, 5.26e-07, 2.20075178215e-07, 5.262e-07, 2.1949310409e-07, 5.264e-07, 2.18924412078e-07, 5.266e-07, 2.18368882912e-07, 5.268e-07, 2.1782628967e-07, 5.27e-07, 2.17296398161e-07, 5.272e-07, 2.16778967318e-07, 5.274e-07, 2.16273749573e-07, 5.276e-07, 2.15780491228e-07, 5.278e-07, 2.15298932812e-07, 5.28e-07, 2.14828809443e-07, 5.282e-07, 2.14369851176e-07, 5.284e-07, 2.13921783347e-07, 5.286e-07, 2.13484326915e-07, 5.288e-07, 2.13057198803e-07, 5.29e-07, 2.12640112225e-07, 5.292e-07, 2.12232777027e-07, 5.294e-07, 2.11834900014e-07, 5.296e-07, 2.11446185277e-07, 5.298e-07, 2.1106633453e-07, 5.3e-07, 2.1069504743e-07, 5.302e-07, 2.10332021913e-07, 5.304e-07, 2.09976954523e-07, 5.306e-07, 2.09629540739e-07, 5.308e-07, 2.09289475311e-07, 5.31e-07, 2.08956452594e-07, 5.312e-07, 2.08630166883e-07, 5.314e-07, 2.08310312749e-07, 5.316e-07, 2.07996585379e-07, 5.318e-07, 2.0768868092e-07, 5.32e-07, 2.07386296817e-07, 5.322e-07, 2.07089132164e-07, 5.324e-07, 2.06796888047e-07, 5.326e-07, 2.06509267892e-07, 5.328e-07, 2.06225977818e-07, 5.33e-07, 2.05946726983e-07, 5.332e-07, 2.05671227938e-07, 5.334e-07, 2.05399196981e-07, 5.336e-07, 2.051303545e-07, 5.338e-07, 2.04864425332e-07, 5.34e-07, 2.04601139108e-07, 5.342e-07, 2.04340230599e-07, 5.344e-07, 2.04081440066e-07, 5.346e-07, 2.03824513594e-07, 5.348e-07, 2.03569203437e-07, 5.35e-07, 2.03315268347e-07, 5.352e-07, 2.03062473903e-07, 5.354e-07, 2.02810592834e-07, 5.356e-07, 2.0255940533e-07, 5.358e-07, 2.02308699353e-07, 5.36e-07, 2.02058270934e-07, 5.362e-07, 2.01807924464e-07, 5.364e-07, 2.01557472967e-07, 5.366e-07, 2.01306738377e-07, 5.368e-07, 2.01055551788e-07, 5.37e-07, 2.00803753698e-07, 5.372e-07, 2.00551194243e-07, 5.374e-07, 2.00297733408e-07, 5.376e-07, 2.00043241235e-07, 5.378e-07, 1.99787598002e-07, 5.38e-07, 1.99530694398e-07, 5.382e-07, 1.99272431674e-07, 5.384e-07, 1.9901272178e-07, 5.386e-07, 1.98751487483e-07, 5.388e-07, 1.98488662465e-07, 5.39e-07, 1.98224191411e-07, 5.392e-07, 1.97958030064e-07, 5.394e-07, 1.97690145273e-07, 5.396e-07, 1.97420515022e-07, 5.398e-07, 1.97149128425e-07, 5.4e-07, 1.96875985722e-07, 5.402e-07, 1.96601098243e-07, 5.404e-07, 1.96324488352e-07, 5.406e-07, 1.96046189382e-07, 5.408e-07, 1.95766245541e-07, 5.41e-07, 1.95484711805e-07, 5.412e-07, 1.95201653793e-07, 5.414e-07, 1.94917147621e-07, 5.416e-07, 1.94631279745e-07, 5.418e-07, 1.9434414678e-07, 5.42e-07, 1.94055855312e-07, 5.422e-07, 1.93766521686e-07, 5.424e-07, 1.93476271787e-07, 5.426e-07, 1.93185240805e-07, 5.428e-07, 1.92893572984e-07, 5.43e-07, 1.92601421365e-07, 5.432e-07, 1.92308947517e-07, 5.434e-07, 1.92016321253e-07, 5.436e-07, 1.91723720342e-07, 5.438e-07, 1.91431330215e-07, 5.44e-07, 1.91139343657e-07, 5.442e-07, 1.90847960497e-07, 5.444e-07, 1.90557387297e-07, 5.446e-07, 1.9026783703e-07, 5.448e-07, 1.89979528758e-07, 5.45e-07, 1.89692687311e-07, 5.452e-07, 1.89407542958e-07, 5.454e-07, 1.89124331087e-07, 5.456e-07, 1.88843291877e-07, 5.458e-07, 1.88564669978e-07, 5.46e-07, 1.88288714189e-07, 5.462e-07, 1.88015677146e-07, 5.464e-07, 1.87745815005e-07, 5.466e-07, 1.87479387139e-07, 5.468e-07, 1.87216655833e-07, 5.47e-07, 1.86957885991e-07, 5.472e-07, 1.86703344848e-07, 5.474e-07, 1.86453301686e-07, 5.476e-07, 1.86208027566e-07, 5.478e-07, 1.85967795056e-07, 5.48e-07, 1.85732877984e-07, 5.482e-07, 1.85503551184e-07, 5.484e-07, 1.85280090264e-07, 5.486e-07, 1.85062771375e-07, 5.488e-07, 1.84851870993e-07, 5.49e-07, 1.84647665717e-07, 5.492e-07, 1.84450432066e-07, 5.494e-07, 1.84260446292e-07, 5.496e-07, 1.84077984209e-07, 5.498e-07, 1.83903321019e-07, 5.5e-07, 1.83736731162e-07, 5.502e-07, 1.83578488166e-07, 5.504e-07, 1.83428864509e-07, 5.506e-07, 1.832881315e-07, 5.508e-07, 1.83156559152e-07, 5.51e-07, 1.83034416081e-07, 5.512e-07, 1.82921969406e-07, 5.514e-07, 1.82819484655e-07, 5.516e-07, 1.82727225689e-07, 5.518e-07, 1.8264545462e-07, 5.52e-07, 1.82574431755e-07, 5.522e-07, 1.82514415528e-07, 5.524e-07, 1.82465662449e-07, 5.526e-07, 1.82428427061e-07, 5.528e-07, 1.82402961896e-07, 5.53e-07, 1.82389517443e-07, 5.532e-07, 1.82388342113e-07, 5.534e-07, 1.82399682215e-07, 5.536e-07, 1.82423781935e-07, 5.538e-07, 1.82460883312e-07, 5.54e-07, 1.82511226228e-07, 5.542e-07, 1.82575048385e-07, 5.544e-07, 1.82652585296e-07, 5.546e-07, 1.82744070276e-07, 5.548e-07, 1.82849734421e-07, 5.55e-07, 1.82969806604e-07, 5.552e-07, 1.83104513456e-07, 5.554e-07, 1.83254079354e-07, 5.556e-07, 1.83418726403e-07, 5.558e-07, 1.83598674417e-07, 5.56e-07, 1.83794140892e-07, 5.562e-07, 1.84005340986e-07, 5.564e-07, 1.84232487479e-07, 5.566e-07, 1.84475790741e-07, 5.568e-07, 1.84735458687e-07, 5.57e-07, 1.85011696728e-07, 5.572e-07, 1.85304707712e-07, 5.574e-07, 1.85614691861e-07, 5.576e-07, 1.85941846693e-07, 5.578e-07, 1.86286366946e-07, 5.58e-07, 1.86648444478e-07, 5.582e-07, 1.87028268165e-07, 5.584e-07, 1.87426023787e-07, 5.586e-07, 1.87841893899e-07, 5.588e-07, 1.88276057691e-07, 5.59e-07, 1.88728690833e-07, 5.592e-07, 1.89199965307e-07, 5.594e-07, 1.89690049224e-07, 5.596e-07, 1.90199106626e-07, 5.598e-07, 1.90727297264e-07, 5.6e-07, 1.91274776374e-07, 5.602e-07, 1.91841694419e-07, 5.604e-07, 1.92428196821e-07, 5.606e-07, 1.93034423671e-07, 5.608e-07, 1.93660509423e-07, 5.61e-07, 1.94306582558e-07, 5.612e-07, 1.94972765237e-07, 5.614e-07, 1.95659172921e-07, 5.616e-07, 1.96365913981e-07, 5.618e-07, 1.9709308927e-07, 5.62e-07, 1.9784079168e-07, 5.622e-07, 1.98609105675e-07, 5.624e-07, 1.9939810679e-07, 5.626e-07, 2.00207861114e-07, 5.628e-07, 2.01038424742e-07, 5.63e-07, 2.01889843196e-07, 5.632e-07, 2.0276215083e-07, 5.634e-07, 2.03655370197e-07, 5.636e-07, 2.04569511391e-07, 5.638e-07, 2.0550457137e-07, 5.64e-07, 2.06460533235e-07, 5.642e-07, 2.074373655e-07, 5.644e-07, 2.0843502132e-07, 5.646e-07, 2.09453437699e-07, 5.648e-07, 2.10492534672e-07, 5.65e-07, 2.1155221446e-07, 5.652e-07, 2.126323606e-07, 5.654e-07, 2.1373283705e-07, 5.656e-07, 2.14853487277e-07, 5.658e-07, 2.15994133318e-07, 5.66e-07, 2.17154574827e-07, 5.662e-07, 2.18334588097e-07, 5.664e-07, 2.19533925078e-07, 5.666e-07, 2.20752312376e-07, 5.668e-07, 2.21989450239e-07, 5.67e-07, 2.23245011546e-07, 5.672e-07, 2.24518640785e-07, 5.674e-07, 2.25809953036e-07, 5.676e-07, 2.27118532956e-07, 5.678e-07, 2.28443933777e-07, 5.68e-07, 2.29785676311e-07, 5.682e-07, 2.31143247989e-07, 5.684e-07, 2.32516101905e-07, 5.686e-07, 2.3390365591e-07, 5.688e-07, 2.35305291729e-07, 5.69e-07, 2.36720354135e-07, 5.692e-07, 2.3814815016e-07, 5.694e-07, 2.39587948379e-07, 5.696e-07, 2.4103897825e-07, 5.698e-07, 2.42500429534e-07, 5.7e-07, 2.43971451794e-07, 5.702e-07, 2.45451153994e-07, 5.704e-07, 2.46938604183e-07, 5.706e-07, 2.48432829309e-07, 5.708e-07, 2.49932815128e-07, 5.71e-07, 2.51437506265e-07, 5.712e-07, 2.52945806389e-07, 5.714e-07, 2.54456578549e-07, 5.716e-07, 2.55968645661e-07, 5.718e-07, 2.57480791151e-07, 5.72e-07, 2.58991759781e-07, 5.722e-07, 2.60500258643e-07, 5.724e-07, 2.62004958345e-07, 5.726e-07, 2.6350449439e-07, 5.728e-07, 2.64997468749e-07, 5.73e-07, 2.66482451642e-07, 5.732e-07, 2.67957983523e-07, 5.734e-07, 2.69422577273e-07, 5.736e-07, 2.70874720613e-07, 5.738e-07, 2.72312878713e-07, 5.74e-07, 2.73735497028e-07, 5.742e-07, 2.75141004326e-07, 5.744e-07, 2.76527815928e-07, 5.746e-07, 2.77894337143e-07, 5.748e-07, 2.79238966884e-07, 5.75e-07, 2.80560101474e-07, 5.752e-07, 2.8185613861e-07, 5.754e-07, 2.83125481483e-07, 5.756e-07, 2.84366543035e-07, 5.758e-07, 2.85577750345e-07, 5.76e-07, 2.86757549102e-07, 5.762e-07, 2.87904408175e-07, 5.764e-07, 2.8901682423e-07, 5.766e-07, 2.90093326395e-07, 5.768e-07, 2.91132480928e-07, 5.77e-07, 2.92132895871e-07, 5.772e-07, 2.93093225672e-07, 5.774e-07, 2.94012175724e-07, 5.776e-07, 2.9488850682e-07, 5.778e-07, 2.95721039482e-07, 5.78e-07, 2.96508658132e-07, 5.782e-07, 2.97250315088e-07, 5.784e-07, 2.97945034357e-07, 5.786e-07, 2.98591915191e-07, 5.788e-07, 2.99190135384e-07, 5.79e-07, 2.997389543e-07, 5.792e-07, 3.00237715589e-07, 5.794e-07, 3.00685849586e-07, 5.796e-07, 3.01082875376e-07, 5.798e-07, 3.014284025e-07, 5.8e-07, 3.01722132301e-07, 5.802e-07, 3.01963858894e-07, 5.804e-07, 3.02153469757e-07, 5.806e-07, 3.02290945934e-07, 5.808e-07, 3.02376361857e-07, 5.81e-07, 3.02409884779e-07, 5.812e-07, 3.02391773839e-07, 5.814e-07, 3.02322378745e-07, 5.816e-07, 3.02202138108e-07, 5.818e-07, 3.02031577424e-07, 5.82e-07, 3.01811306727e-07, 5.822e-07, 3.01542017933e-07, 5.824e-07, 3.0122448189e-07, 5.826e-07, 3.00859545154e-07, 5.828e-07, 3.00448126525e-07, 5.83e-07, 2.99991213358e-07, 5.832e-07, 2.99489857676e-07, 5.834e-07, 2.98945172112e-07, 5.836e-07, 2.98358325719e-07, 5.838e-07, 2.97730539643e-07, 5.84e-07, 2.97063082732e-07, 5.842e-07, 2.96357267059e-07, 5.844e-07, 2.95614443428e-07, 5.846e-07, 2.94835996857e-07, 5.848e-07, 2.94023342078e-07, 5.85e-07, 2.93177919076e-07, 5.852e-07, 2.92301188685e-07, 5.854e-07, 2.91394628262e-07, 5.856e-07, 2.9045972746e-07, 5.858e-07, 2.89497984118e-07, 5.86e-07, 2.88510900277e-07, 5.862e-07, 2.87499978351e-07, 5.864e-07, 2.86466717444e-07, 5.866e-07, 2.85412609842e-07, 5.868e-07, 2.84339137677e-07, 5.87e-07, 2.83247769779e-07, 5.872e-07, 2.82139958714e-07, 5.874e-07, 2.81017138013e-07, 5.876e-07, 2.79880719602e-07, 5.878e-07, 2.7873209142e-07, 5.88e-07, 2.77572615243e-07, 5.882e-07, 2.76403624689e-07, 5.884e-07, 2.7522642343e-07, 5.886e-07, 2.74042283579e-07, 5.888e-07, 2.72852444267e-07, 5.89e-07, 2.71658110397e-07, 5.892e-07, 2.70460451569e-07, 5.894e-07, 2.69260601174e-07, 5.896e-07, 2.68059655639e-07, 5.898e-07, 2.66858673833e-07, 5.9e-07, 2.65658676607e-07, 5.902e-07, 2.64460646479e-07, 5.904e-07, 2.63265527433e-07, 5.906e-07, 2.6207422485e-07, 5.908e-07, 2.60887605545e-07, 5.91e-07, 2.597064979e-07, 5.912e-07, 2.58531692104e-07, 5.914e-07, 2.57363940469e-07, 5.916e-07, 2.56203957828e-07, 5.918e-07, 2.55052422011e-07, 5.92e-07, 2.53909974372e-07, 5.922e-07, 2.52777220384e-07, 5.924e-07, 2.51654730283e-07, 5.926e-07, 2.50543039751e-07, 5.928e-07, 2.49442650641e-07, 5.93e-07, 2.48354031736e-07, 5.932e-07, 2.4727761953e-07, 5.934e-07, 2.46213819035e-07, 5.936e-07, 2.45163004605e-07, 5.938e-07, 2.44125520775e-07, 5.94e-07, 2.431016831e-07, 5.942e-07, 2.42091779012e-07, 5.944e-07, 2.41096068672e-07, 5.946e-07, 2.4011478582e-07, 5.948e-07, 2.39148138624e-07, 5.95e-07, 2.38196310522e-07, 5.952e-07, 2.37259461057e-07, 5.954e-07, 2.36337726696e-07, 5.956e-07, 2.35431221645e-07, 5.958e-07, 2.34540038643e-07, 5.96e-07, 2.33664249742e-07, 5.962e-07, 2.32803907077e-07, 5.964e-07, 2.31959043613e-07, 5.966e-07, 2.31129673873e-07, 5.968e-07, 2.30315794655e-07, 5.97e-07, 2.29517385723e-07, 5.972e-07, 2.28734410482e-07, 5.974e-07, 2.27966816635e-07, 5.976e-07, 2.27214536819e-07, 5.978e-07, 2.26477489225e-07, 5.98e-07, 2.25755578193e-07, 5.982e-07, 2.25048694795e-07, 5.984e-07, 2.24356717399e-07, 5.986e-07, 2.23679512208e-07, 5.988e-07, 2.23016933796e-07, 5.99e-07, 2.22368825612e-07, 5.992e-07, 2.21735020476e-07, 5.994e-07, 2.21115341062e-07, 5.996e-07, 2.20509600362e-07, 5.998e-07, 2.19917602131e-07, 6e-07, 2.19339141335e-07, 6.002e-07, 2.18774004567e-07, 6.004e-07, 2.18221970466e-07, 6.006e-07, 2.17682810121e-07, 6.008e-07, 2.17156287457e-07, 6.01e-07, 2.16642159626e-07, 6.012e-07, 2.16140177379e-07, 6.014e-07, 2.1565008543e-07, 6.016e-07, 2.15171622824e-07, 6.018e-07, 2.14704523285e-07, 6.02e-07, 2.14248515566e-07, 6.022e-07, 2.13803323797e-07, 6.024e-07, 2.13368667819e-07, 6.026e-07, 2.12944263527e-07, 6.028e-07, 2.12529823198e-07, 6.03e-07, 2.1212505583e-07, 6.032e-07, 2.11729667467e-07, 6.034e-07, 2.11343361529e-07, 6.036e-07, 2.10965839146e-07, 6.038e-07, 2.1059679948e-07, 6.04e-07, 2.10235940062e-07, 6.042e-07, 2.09882957116e-07, 6.044e-07, 2.09537545894e-07, 6.046e-07, 2.09199401007e-07, 6.048e-07, 2.08868216761e-07, 6.05e-07, 2.08543687491e-07, 6.052e-07, 2.082255079e-07, 6.054e-07, 2.079133734e-07, 6.056e-07, 2.07606980451e-07, 6.058e-07, 2.07306026909e-07, 6.06e-07, 2.07010212367e-07, 6.062e-07, 2.06719238506e-07, 6.064e-07, 2.06432809439e-07, 6.066e-07, 2.06150632067e-07, 6.068e-07, 2.05872416425e-07, 6.07e-07, 2.05597876035e-07, 6.072e-07, 2.05326728257e-07, 6.074e-07, 2.05058694642e-07, 6.076e-07, 2.04793501277e-07, 6.078e-07, 2.04530879139e-07, 6.08e-07, 2.04270564441e-07, 6.082e-07, 2.04012298971e-07, 6.084e-07, 2.03755830439e-07, 6.086e-07, 2.03500912811e-07, 6.088e-07, 2.03247306639e-07, 6.09e-07, 2.0299477939e-07, 6.092e-07, 2.02743105764e-07, 6.094e-07, 2.0249206801e-07, 6.096e-07, 2.02241456225e-07, 6.098e-07, 2.01991068658e-07, 6.1e-07, 2.01740711988e-07, 6.102e-07, 2.01490201607e-07, 6.104e-07, 2.01239361883e-07, 6.106e-07, 2.0098802641e-07, 6.108e-07, 2.00736038252e-07, 6.11e-07, 2.00483250167e-07, 6.112e-07, 2.00229524822e-07, 6.114e-07, 1.99974734988e-07, 6.116e-07, 1.99718763723e-07, 6.118e-07, 1.99461504535e-07, 6.12e-07, 1.99202861537e-07, 6.122e-07, 1.98942749569e-07, 6.124e-07, 1.98681094321e-07, 6.126e-07, 1.9841783242e-07, 6.128e-07, 1.98152911514e-07, 6.13e-07, 1.97886290325e-07, 6.132e-07, 1.97617938689e-07, 6.134e-07, 1.97347837576e-07, 6.136e-07, 1.97075979092e-07, 6.138e-07, 1.96802366456e-07, 6.14e-07, 1.96527013965e-07, 6.142e-07, 1.96249946938e-07, 6.144e-07, 1.95971201634e-07, 6.146e-07, 1.95690825165e-07, 6.148e-07, 1.95408875376e-07, 6.15e-07, 1.95125420718e-07, 6.152e-07, 1.94840540101e-07, 6.154e-07, 1.94554322725e-07, 6.156e-07, 1.94266867901e-07, 6.158e-07, 1.93978284855e-07, 6.16e-07, 1.93688692517e-07, 6.162e-07, 1.93398219292e-07, 6.164e-07, 1.93107002826e-07, 6.166e-07, 1.9281518975e-07, 6.168e-07, 1.92522935422e-07, 6.17e-07, 1.9223040365e-07, 6.172e-07, 1.91937766413e-07, 6.174e-07, 1.91645203567e-07, 6.176e-07, 1.91352902545e-07, 6.178e-07, 1.91061058054e-07, 6.18e-07, 1.90769871763e-07, 6.182e-07, 1.90479551985e-07, 6.184e-07, 1.9019031336e-07, 6.186e-07, 1.89902376531e-07, 6.188e-07, 1.89615967817e-07, 6.19e-07, 1.89331318896e-07, 6.192e-07, 1.89048666473e-07, 6.194e-07, 1.88768251957e-07, 6.196e-07, 1.88490321145e-07, 6.198e-07, 1.88215123896e-07, 6.2e-07, 1.87942913822e-07, 6.202e-07, 1.87673947972e-07, 6.204e-07, 1.87408486531e-07, 6.206e-07, 1.87146792514e-07, 6.208e-07, 1.8688913148e-07, 6.21e-07, 1.86635771241e-07, 6.212e-07, 1.86386981582e-07, 6.214e-07, 1.86143033994e-07, 6.216e-07, 1.85904201409e-07, 6.218e-07, 1.85670757948e-07, 6.22e-07, 1.85442978677e-07, 6.222e-07, 1.8522113937e-07, 6.224e-07, 1.85005516287e-07, 6.226e-07, 1.84796385958e-07, 6.228e-07, 1.84594024977e-07, 6.23e-07, 1.84398709811e-07, 6.232e-07, 1.84210716612e-07, 6.234e-07, 1.84030321044e-07, 6.236e-07, 1.83857798121e-07, 6.238e-07, 1.8369342205e-07, 6.24e-07, 1.83537466092e-07, 6.242e-07, 1.83390202423e-07, 6.244e-07, 1.83251902013e-07, 6.246e-07, 1.83122834514e-07, 6.248e-07, 1.83003268147e-07, 6.25e-07, 1.82893469612e-07, 6.252e-07, 1.82793703999e-07, 6.254e-07, 1.82704234705e-07, 6.256e-07, 1.82625323365e-07, 6.258e-07, 1.82557229788e-07, 6.26e-07, 1.82500211895e-07, 6.262e-07, 1.82454525675e-07, 6.264e-07, 1.82420425134e-07, 6.266e-07, 1.82398162259e-07, 6.268e-07, 1.82387986982e-07, 6.27e-07, 1.82390147155e-07, 6.272e-07, 1.82404888517e-07, 6.274e-07, 1.82432454682e-07, 6.276e-07, 1.82473087109e-07, 6.278e-07, 1.82527025097e-07, 6.28e-07, 1.82594505761e-07, 6.282e-07, 1.82675764028e-07, 6.284e-07, 1.82771032615e-07, 6.286e-07, 1.82880542024e-07, 6.288e-07, 1.83004520528e-07, 6.29e-07, 1.83143194154e-07, 6.292e-07, 1.83296786672e-07, 6.294e-07, 1.83465519572e-07, 6.296e-07, 1.83649612049e-07, 6.298e-07, 1.83849280975e-07, 6.3e-07, 1.84064740872e-07, 6.302e-07, 1.84296203878e-07, 6.304e-07, 1.84543879707e-07, 6.306e-07, 1.8480797561e-07, 6.308e-07, 1.85088696312e-07, 6.31e-07, 1.85386243966e-07, 6.312e-07, 1.85700818074e-07, 6.314e-07, 1.86032615417e-07, 6.316e-07, 1.86381829969e-07, 6.318e-07, 1.86748652799e-07, 6.32e-07, 1.87133271963e-07, 6.322e-07, 1.87535872389e-07, 6.324e-07, 1.87956635743e-07, 6.326e-07, 1.88395740285e-07, 6.328e-07, 1.88853360712e-07, 6.33e-07, 1.89329667988e-07, 6.332e-07, 1.89824829149e-07, 6.334e-07, 1.90339007108e-07, 6.336e-07, 1.90872360429e-07, 6.338e-07, 1.91425043091e-07, 6.34e-07, 1.9199720423e-07, 6.342e-07, 1.92588987868e-07, 6.344e-07, 1.93200532614e-07, 6.346e-07, 1.93831971351e-07, 6.348e-07, 1.944834309e-07, 6.35e-07, 1.9515503166e-07, 6.352e-07, 1.9584688723e-07, 6.354e-07, 1.96559104004e-07, 6.356e-07, 1.97291780743e-07, 6.358e-07, 1.98045008124e-07, 6.36e-07, 1.98818868265e-07, 6.362e-07, 1.99613434216e-07, 6.364e-07, 2.00428769439e-07, 6.366e-07, 2.01264927248e-07, 6.368e-07, 2.02121950227e-07, 6.37e-07, 2.02999869626e-07, 6.372e-07, 2.03898704718e-07, 6.374e-07, 2.04818462141e-07, 6.376e-07, 2.05759135201e-07, 6.378e-07, 2.06720703161e-07, 6.38e-07, 2.07703130485e-07, 6.382e-07, 2.08706366073e-07, 6.384e-07, 2.09730342456e-07, 6.386e-07, 2.1077497497e-07, 6.388e-07, 2.11840160908e-07, 6.39e-07, 2.12925778638e-07, 6.392e-07, 2.14031686711e-07, 6.394e-07, 2.15157722932e-07, 6.396e-07, 2.16303703425e-07, 6.398e-07, 2.17469421668e-07, 6.4e-07, 2.18654647519e-07, 6.402e-07, 2.19859126222e-07, 6.404e-07, 2.21082577408e-07, 6.406e-07, 2.22324694077e-07, 6.408e-07, 2.23585141588e-07, 6.41e-07, 2.24863556635e-07, 6.412e-07, 2.26159546229e-07, 6.414e-07, 2.2747268669e-07, 6.416e-07, 2.28802522644e-07, 6.418e-07, 2.30148566037e-07, 6.42e-07, 2.31510295173e-07, 6.422e-07, 2.32887153776e-07, 6.424e-07, 2.34278550082e-07, 6.426e-07, 2.35683855978e-07, 6.428e-07, 2.37102406179e-07, 6.43e-07, 2.38533497463e-07, 6.432e-07, 2.39976387966e-07, 6.434e-07, 2.41430296542e-07, 6.436e-07, 2.42894402209e-07, 6.438e-07, 2.44367843666e-07, 6.44e-07, 2.45849718921e-07, 6.442e-07, 2.47339085004e-07, 6.444e-07, 2.48834957808e-07, 6.446e-07, 2.50336312038e-07, 6.448e-07, 2.518420813e-07, 6.45e-07, 2.53351158321e-07, 6.452e-07, 2.54862395323e-07, 6.454e-07, 2.5637460455e-07, 6.456e-07, 2.57886558963e-07, 6.458e-07, 2.59396993104e-07, 6.46e-07, 2.60904604148e-07, 6.462e-07, 2.62408053136e-07, 6.464e-07, 2.63905966408e-07, 6.466e-07, 2.65396937227e-07, 6.468e-07, 2.6687952762e-07, 6.47e-07, 2.68352270415e-07, 6.472e-07, 2.69813671494e-07, 6.474e-07, 2.71262212259e-07, 6.476e-07, 2.72696352301e-07, 6.478e-07, 2.74114532289e-07, 6.48e-07, 2.75515177056e-07, 6.482e-07, 2.76896698889e-07, 6.484e-07, 2.78257501018e-07, 6.486e-07, 2.79595981281e-07, 6.488e-07, 2.80910535973e-07, 6.49e-07, 2.82199563854e-07, 6.492e-07, 2.8346147031e-07, 6.494e-07, 2.84694671645e-07, 6.496e-07, 2.85897599487e-07, 6.498e-07, 2.87068705298e-07, 6.5e-07, 2.88206464951e-07, 6.502e-07, 2.89309383371e-07, 6.504e-07, 2.90375999192e-07, 6.506e-07, 2.91404889434e-07, 6.508e-07, 2.92394674144e-07, 6.51e-07, 2.93344021001e-07, 6.512e-07, 2.9425164984e-07, 6.514e-07, 2.95116337068e-07, 6.516e-07, 2.95936919955e-07, 6.518e-07, 2.96712300766e-07, 6.52e-07, 2.974414507e-07, 6.522e-07, 2.98123413624e-07, 6.524e-07, 2.98757309558e-07, 6.526e-07, 2.99342337912e-07, 6.528e-07, 2.99877780418e-07, 6.53e-07, 3.00363003774e-07, 6.532e-07, 3.00797461952e-07, 6.534e-07, 3.01180698165e-07, 6.536e-07, 3.01512346481e-07, 6.538e-07, 3.01792133065e-07, 6.54e-07, 3.02019877055e-07, 6.542e-07, 3.02195491039e-07, 6.544e-07, 3.02318981165e-07, 6.546e-07, 3.02390446851e-07, 6.548e-07, 3.02410080125e-07, 6.55e-07, 3.02378164581e-07, 6.552e-07, 3.0229507397e-07, 6.554e-07, 3.02161270439e-07, 6.556e-07, 3.0197730242e-07, 6.558e-07, 3.01743802203e-07, 6.56e-07, 3.0146148319e-07, 6.562e-07, 3.01131136881e-07, 6.564e-07, 3.00753629575e-07, 6.566e-07, 3.00329898844e-07, 6.568e-07, 2.99860949793e-07, 6.57e-07, 2.99347851118e-07, 6.572e-07, 2.98791731016e-07, 6.574e-07, 2.98193772951e-07, 6.576e-07, 2.9755521131e-07, 6.578e-07, 2.96877326983e-07, 6.58e-07, 2.96161442885e-07, 6.582e-07, 2.95408919446e-07, 6.584e-07, 2.94621150101e-07, 6.586e-07, 2.93799556797e-07, 6.588e-07, 2.92945585546e-07, 6.59e-07, 2.92060702037e-07, 6.592e-07, 2.9114638734e-07, 6.594e-07, 2.90204133701e-07, 6.596e-07, 2.89235440475e-07, 6.598e-07, 2.88241810172e-07, 6.6e-07, 2.87224744672e-07, 6.602e-07, 2.86185741586e-07, 6.604e-07, 2.85126290795e-07, 6.606e-07, 2.84047871161e-07, 6.608e-07, 2.82951947431e-07, 6.61e-07, 2.81839967326e-07, 6.612e-07, 2.80713358821e-07, 6.614e-07, 2.79573527629e-07, 6.616e-07, 2.78421854871e-07, 6.618e-07, 2.77259694953e-07, 6.62e-07, 2.76088373622e-07, 6.622e-07, 2.74909186228e-07, 6.624e-07, 2.73723396164e-07, 6.626e-07, 2.72532233488e-07, 6.628e-07, 2.71336893724e-07, 6.63e-07, 2.70138536835e-07, 6.632e-07, 2.68938286356e-07, 6.634e-07, 2.67737228686e-07, 6.636e-07, 2.66536412528e-07, 6.638e-07, 2.65336848468e-07, 6.64e-07, 2.64139508693e-07, 6.642e-07, 2.6294532683e-07, 6.644e-07, 2.61755197897e-07, 6.646e-07, 2.60569978375e-07, 6.648e-07, 2.59390486368e-07, 6.65e-07, 2.58217501862e-07, 6.652e-07, 2.57051767065e-07, 6.654e-07, 2.5589398683e-07, 6.656e-07, 2.54744829139e-07, 6.658e-07, 2.53604925654e-07, 6.66e-07, 2.52474872325e-07, 6.662e-07, 2.51355230043e-07, 6.664e-07, 2.50246525337e-07, 6.666e-07, 2.49149251106e-07, 6.668e-07, 2.48063867388e-07, 6.67e-07, 2.46990802146e-07, 6.672e-07, 2.45930452081e-07, 6.674e-07, 2.44883183461e-07, 6.676e-07, 2.43849332956e-07, 6.678e-07, 2.42829208491e-07, 6.68e-07, 2.41823090091e-07, 6.682e-07, 2.40831230743e-07, 6.684e-07, 2.39853857238e-07, 6.686e-07, 2.38891171024e-07, 6.688e-07, 2.37943349043e-07, 6.69e-07, 2.37010544564e-07, 6.692e-07, 2.36092887999e-07, 6.694e-07, 2.35190487713e-07, 6.696e-07, 2.34303430816e-07, 6.698e-07, 2.3343178394e-07, 6.7e-07, 2.32575594001e-07, 6.702e-07, 2.31734888942e-07, 6.704e-07, 2.30909678459e-07, 6.706e-07, 2.30099954709e-07, 6.708e-07, 2.29305693001e-07, 6.71e-07, 2.2852685246e-07, 6.712e-07, 2.27763376685e-07, 6.714e-07, 2.27015194373e-07, 6.716e-07, 2.2628221994e-07, 6.718e-07, 2.25564354107e-07, 6.72e-07, 2.24861484483e-07, 6.722e-07, 2.24173486116e-07, 6.724e-07, 2.23500222039e-07, 6.726e-07, 2.22841543786e-07, 6.728e-07, 2.22197291908e-07, 6.73e-07, 2.21567296455e-07, 6.732e-07, 2.20951377455e-07, 6.734e-07, 2.20349345378e-07, 6.736e-07, 2.19761001577e-07, 6.738e-07, 2.19186138729e-07, 6.74e-07, 2.18624541252e-07, 6.742e-07, 2.1807598572e-07, 6.744e-07, 2.17540241258e-07, 6.746e-07, 2.17017069939e-07, 6.748e-07, 2.16506227157e-07, 6.75e-07, 2.16007462009e-07, 6.752e-07, 2.15520517651e-07, 6.754e-07, 2.15045131666e-07, 6.756e-07, 2.14581036409e-07, 6.758e-07, 2.14127959358e-07, 6.76e-07, 2.13685623459e-07, 6.762e-07, 2.13253747461e-07, 6.764e-07, 2.12832046255e-07, 6.766e-07, 2.12420231204e-07, 6.768e-07, 2.12018010482e-07, 6.77e-07, 2.11625089396e-07, 6.772e-07, 2.11241170719e-07, 6.774e-07, 2.1086595502e-07, 6.776e-07, 2.10499140992e-07, 6.778e-07, 2.10140425781e-07, 6.78e-07, 2.09789505318e-07, 6.782e-07, 2.09446074651e-07, 6.784e-07, 2.09109828275e-07, 6.786e-07, 2.08780460471e-07, 6.788e-07, 2.08457665641e-07, 6.79e-07, 2.08141138643e-07, 6.792e-07, 2.07830575138e-07, 6.794e-07, 2.07525671927e-07, 6.796e-07, 2.07226127297e-07, 6.798e-07, 2.06931641368e-07, 6.8e-07, 2.06641916439e-07, 6.802e-07, 2.06356657338e-07, 6.804e-07, 2.06075571772e-07, 6.806e-07, 2.05798370678e-07, 6.808e-07, 2.05524768574e-07, 6.81e-07, 2.0525448391e-07, 6.812e-07, 2.0498723942e-07, 6.814e-07, 2.0472276247e-07, 6.816e-07, 2.0446078541e-07, 6.818e-07, 2.04201045913e-07, 6.82e-07, 2.03943287325e-07, 6.822e-07, 2.03687259003e-07, 6.824e-07, 2.03432716648e-07, 6.826e-07, 2.03179422636e-07, 6.828e-07, 2.02927146344e-07, 6.83e-07, 2.0267566447e-07, 6.832e-07, 2.02424761339e-07, 6.834e-07, 2.02174229207e-07, 6.836e-07, 2.01923868559e-07, 6.838e-07, 2.01673488386e-07, 6.84e-07, 2.01422906464e-07, 6.842e-07, 2.01171949613e-07, 6.844e-07, 2.00920453946e-07, 6.846e-07, 2.00668265108e-07, 6.848e-07, 2.00415238497e-07, 6.85e-07, 2.00161239473e-07, 6.852e-07, 1.99906143551e-07, 6.854e-07, 1.99649836579e-07, 6.856e-07, 1.99392214898e-07, 6.858e-07, 1.99133185488e-07, 6.86e-07, 1.98872666091e-07, 6.862e-07, 1.98610585325e-07, 6.864e-07, 1.98346882768e-07, 6.866e-07, 1.98081509036e-07, 6.868e-07, 1.97814425831e-07, 6.87e-07, 1.97545605978e-07, 6.872e-07, 1.97275033435e-07, 6.874e-07, 1.97002703296e-07, 6.876e-07, 1.96728621757e-07, 6.878e-07, 1.9645280608e-07, 6.88e-07, 1.96175284529e-07, 6.882e-07, 1.95896096288e-07, 6.884e-07, 1.95615291359e-07, 6.886e-07, 1.9533293045e-07, 6.888e-07, 1.95049084834e-07, 6.89e-07, 1.94763836201e-07, 6.892e-07, 1.94477276481e-07, 6.894e-07, 1.9418950767e-07, 6.896e-07, 1.93900641618e-07, 6.898e-07, 1.93610799822e-07, 6.9e-07, 1.93320113191e-07, 6.902e-07, 1.93028721808e-07, 6.904e-07, 1.92736774673e-07, 6.906e-07, 1.92444429441e-07, 6.908e-07, 1.92151852139e-07, 6.91e-07, 1.91859216892e-07, 6.912e-07, 1.91566705617e-07, 6.914e-07, 1.91274507732e-07, 6.916e-07, 1.90982819843e-07, 6.918e-07, 1.90691845433e-07, 6.92e-07, 1.90401794546e-07, 6.922e-07, 1.90112883464e-07, 6.924e-07, 1.89825334387e-07, 6.926e-07, 1.89539375103e-07, 6.928e-07, 1.89255238672e-07, 6.93e-07, 1.88973163093e-07, 6.932e-07, 1.88693390985e-07, 6.934e-07, 1.88416169267e-07, 6.936e-07, 1.88141748835e-07, 6.938e-07, 1.87870384254e-07, 6.94e-07, 1.87602333446e-07, 6.942e-07, 1.87337857382e-07, 6.944e-07, 1.87077219792e-07, 6.946e-07, 1.86820686866e-07, 6.948e-07, 1.86568526972e-07, 6.95e-07, 1.8632101038e-07, 6.952e-07, 1.86078408993e-07, 6.954e-07, 1.85840996087e-07, 6.956e-07, 1.8560904606e-07, 6.958e-07, 1.8538283419e-07, 6.96e-07, 1.85162636404e-07, 6.962e-07, 1.84948729055e-07, 6.964e-07, 1.8474138871e-07, 6.966e-07, 1.84540891948e-07, 6.968e-07, 1.84347515168e-07, 6.97e-07, 1.84161534408e-07, 6.972e-07, 1.83983225173e-07, 6.974e-07, 1.83812862276e-07, 6.976e-07, 1.83650719682e-07, 6.978e-07, 1.83497070375e-07, 6.98e-07, 1.83352186219e-07, 6.982e-07, 1.83216337842e-07, 6.984e-07, 1.83089794518e-07, 6.986e-07, 1.82972824073e-07, 6.988e-07, 1.82865692782e-07, 6.99e-07, 1.82768665286e-07, 6.992e-07, 1.82682004518e-07, 6.994e-07, 1.82605971629e-07, 6.996e-07, 1.82540825925e-07, 6.998e-07, 1.82486824814e-07, 7e-07, 1.82444223756e-07, 7.002e-07, 1.8241327622e-07, 7.004e-07, 1.82394233643e-07, 7.006e-07, 1.82387345404e-07, 7.008e-07, 1.82392858787e-07, 7.01e-07, 1.82411018964e-07, 7.012e-07, 1.82442068972e-07, 7.014e-07, 1.82486249692e-07, 7.016e-07, 1.82543799838e-07, 7.018e-07, 1.8261495594e-07, 7.02e-07, 1.8269995233e-07, 7.022e-07, 1.82799021134e-07, 7.024e-07, 1.82912392257e-07, 7.026e-07, 1.83040293369e-07, 7.028e-07, 1.83182949894e-07, 7.03e-07, 1.83340584991e-07, 7.032e-07, 1.83513419536e-07, 7.034e-07, 1.83701672105e-07, 7.036e-07, 1.8390555894e-07, 7.038e-07, 1.84125293926e-07, 7.04e-07, 1.84361088557e-07, 7.042e-07, 1.84613151889e-07, 7.044e-07, 1.848816905e-07, 7.046e-07, 1.85166908431e-07, 7.048e-07, 1.8546900713e-07, 7.05e-07, 1.85788185377e-07, 7.052e-07, 1.86124639209e-07, 7.054e-07, 1.8647856183e-07, 7.056e-07, 1.86850143509e-07, 7.058e-07, 1.87239571477e-07, 7.06e-07, 1.87647029798e-07, 7.062e-07, 1.88072699239e-07, 7.064e-07, 1.8851675712e-07, 7.066e-07, 1.88979377154e-07, 7.068e-07, 1.89460729268e-07, 7.07e-07, 1.89960979414e-07, 7.072e-07, 1.90480289359e-07, 7.074e-07, 1.91018816459e-07, 7.076e-07, 1.9157671342e-07, 7.078e-07, 1.92154128034e-07, 7.08e-07, 1.92751202898e-07, 7.082e-07, 1.93368075116e-07, 7.084e-07, 1.94004875979e-07, 7.086e-07, 1.94661730619e-07, 7.088e-07, 1.95338757648e-07, 7.09e-07, 1.96036068773e-07, 7.092e-07, 1.96753768379e-07, 7.094e-07, 1.97491953106e-07, 7.096e-07, 1.98250711379e-07, 7.098e-07, 1.99030122931e-07, 7.1e-07, 1.99830258295e-07, 7.102e-07, 2.00651178262e-07, 7.104e-07, 2.01492933323e-07, 7.106e-07, 2.02355563084e-07, 7.108e-07, 2.03239095639e-07, 7.11e-07, 2.04143546939e-07, 7.112e-07, 2.05068920111e-07, 7.114e-07, 2.06015204764e-07, 7.116e-07, 2.06982376261e-07, 7.118e-07, 2.07970394967e-07, 7.12e-07, 2.08979205467e-07, 7.122e-07, 2.10008735758e-07, 7.124e-07, 2.11058896417e-07, 7.126e-07, 2.12129579744e-07, 7.128e-07, 2.13220658878e-07, 7.13e-07, 2.1433198689e-07, 7.132e-07, 2.15463395861e-07, 7.134e-07, 2.16614695929e-07, 7.136e-07, 2.17785674329e-07, 7.138e-07, 2.1897609441e-07, 7.14e-07, 2.20185694638e-07, 7.142e-07, 2.21414187595e-07, 7.144e-07, 2.22661258963e-07, 7.146e-07, 2.23926566505e-07, 7.148e-07, 2.25209739046e-07, 7.15e-07, 2.26510375458e-07, 7.152e-07, 2.27828043652e-07, 7.154e-07, 2.29162279577e-07, 7.156e-07, 2.30512586241e-07, 7.158e-07, 2.31878432758e-07, 7.16e-07, 2.3325925341e-07, 7.162e-07, 2.34654446762e-07, 7.164e-07, 2.360633748e-07, 7.166e-07, 2.37485362127e-07, 7.168e-07, 2.38919695216e-07, 7.17e-07, 2.40365621717e-07, 7.172e-07, 2.41822349843e-07, 7.174e-07, 2.43289047831e-07, 7.176e-07, 2.44764843491e-07, 7.178e-07, 2.46248823853e-07, 7.18e-07, 2.47740034917e-07, 7.182e-07, 2.49237481518e-07, 7.184e-07, 2.50740127315e-07, 7.186e-07, 2.52246894912e-07, 7.188e-07, 2.53756666121e-07, 7.19e-07, 2.55268282373e-07, 7.192e-07, 2.56780545293e-07, 7.194e-07, 2.58292217434e-07, 7.196e-07, 2.598020232e-07, 7.198e-07, 2.61308649936e-07, 7.2e-07, 2.62810749218e-07, 7.202e-07, 2.6430693834e-07, 7.204e-07, 2.6579580199e-07, 7.206e-07, 2.67275894149e-07, 7.208e-07, 2.68745740181e-07, 7.21e-07, 2.70203839146e-07, 7.212e-07, 2.7164866632e-07, 7.214e-07, 2.73078675924e-07, 7.216e-07, 2.74492304063e-07, 7.218e-07, 2.75887971872e-07, 7.22e-07, 2.77264088856e-07, 7.222e-07, 2.78619056429e-07, 7.224e-07, 2.79951271631e-07, 7.226e-07, 2.81259131018e-07, 7.228e-07, 2.82541034715e-07, 7.23e-07, 2.83795390613e-07, 7.232e-07, 2.8502061869e-07, 7.234e-07, 2.86215155454e-07, 7.236e-07, 2.87377458467e-07, 7.238e-07, 2.88506010944e-07, 7.24e-07, 2.89599326399e-07, 7.242e-07, 2.90655953313e-07, 7.244e-07, 2.916744798e-07, 7.246e-07, 2.92653538246e-07, 7.248e-07, 2.9359180989e-07, 7.25e-07, 2.94488029322e-07, 7.252e-07, 2.95340988874e-07, 7.254e-07, 2.96149542863e-07, 7.256e-07, 2.96912611681e-07, 7.258e-07, 2.97629185677e-07, 7.26e-07, 2.98298328827e-07, 7.262e-07, 2.98919182157e-07, 7.264e-07, 2.99490966899e-07, 7.266e-07, 3.00012987347e-07, 7.268e-07, 3.00484633415e-07, 7.27e-07, 3.0090538285e-07, 7.272e-07, 3.0127480311e-07, 7.274e-07, 3.0159255288e-07, 7.276e-07, 3.01858383214e-07, 7.278e-07, 3.020721383e-07, 7.28e-07, 3.02233755851e-07, 7.282e-07, 3.02343267092e-07, 7.284e-07, 3.02400796384e-07, 7.286e-07, 3.02406560453e-07, 7.288e-07, 3.02360867246e-07, 7.29e-07, 3.02264114432e-07, 7.292e-07, 3.0211678754e-07, 7.294e-07, 3.01919457764e-07, 7.296e-07, 3.01672779449e-07, 7.298e-07, 3.01377487271e-07, 7.3e-07, 3.01034393139e-07, 7.302e-07, 3.00644382843e-07, 7.304e-07, 3.00208412458e-07, 7.306e-07, 2.99727504554e-07, 7.308e-07, 2.99202744206e-07, 7.31e-07, 2.98635274868e-07, 7.312e-07, 2.98026294104e-07, 7.314e-07, 2.97377049221e-07, 7.316e-07, 2.96688832831e-07, 7.318e-07, 2.95962978362e-07, 7.32e-07, 2.95200855548e-07, 7.322e-07, 2.94403865917e-07, 7.324e-07, 2.9357343831e-07, 7.326e-07, 2.92711024449e-07, 7.328e-07, 2.91818094569e-07, 7.33e-07, 2.90896133148e-07, 7.332e-07, 2.89946634736e-07, 7.334e-07, 2.88971099914e-07, 7.336e-07, 2.87971031392e-07, 7.338e-07, 2.86947930253e-07, 7.34e-07, 2.85903292365e-07, 7.342e-07, 2.84838604965e-07, 7.344e-07, 2.83755343426e-07, 7.346e-07, 2.826549682e-07, 7.348e-07, 2.81538921966e-07, 7.35e-07, 2.80408626963e-07, 7.352e-07, 2.79265482523e-07, 7.354e-07, 2.78110862796e-07, 7.356e-07, 2.76946114677e-07, 7.358e-07, 2.75772555918e-07, 7.36e-07, 2.74591473436e-07, 7.362e-07, 2.73404121801e-07, 7.364e-07, 2.72211721913e-07, 7.366e-07, 2.71015459845e-07, 7.368e-07, 2.69816485858e-07, 7.37e-07, 2.68615913584e-07, 7.372e-07, 2.67414819349e-07, 7.374e-07, 2.66214241661e-07)'
Csh ns n Q = '(pwl(time, 0, 3.59484462331e-11, 2e-10, 3.58777197085e-11, 4e-10, 3.58095773342e-11, 6e-10, 3.57440735029e-11, 8e-10, 3.56812622356e-11, 1e-09, 3.56211971895e-11, 1.2e-09, 3.55639316688e-11, 1.4e-09, 3.55095186373e-11, 1.6e-09, 3.54580107339e-11, 1.8e-09, 3.54094602895e-11, 2e-09, 3.53639193457e-11, 2.2e-09, 3.53214396757e-11, 2.4e-09, 3.52820728069e-11, 2.6e-09, 3.52458700446e-11, 2.8e-09, 3.52128824976e-11, 3e-09, 3.51831611048e-11, 3.2e-09, 3.51567566631e-11, 3.4e-09, 3.51337198569e-11, 3.6e-09, 3.51141012873e-11, 3.8e-09, 3.5097951504e-11, 4e-09, 3.50853210364e-11, 4.2e-09, 3.50762604259e-11, 4.4e-09, 3.50708202595e-11, 4.6e-09, 3.50690512023e-11, 4.8e-09, 3.50710040318e-11, 5e-09, 3.50767296718e-11, 5.2e-09, 3.50862792264e-11, 5.4e-09, 3.50997040141e-11, 5.6e-09, 3.51170556019e-11, 5.8e-09, 3.51383858394e-11, 6e-09, 3.51637468922e-11, 6.2e-09, 3.5193191275e-11, 6.4e-09, 3.52267718848e-11, 6.6e-09, 3.52645420327e-11, 6.8e-09, 3.53065554753e-11, 7e-09, 3.53528664455e-11, 7.2e-09, 3.54035296823e-11, 7.4e-09, 3.5458600459e-11, 7.6e-09, 3.55181346111e-11, 7.8e-09, 3.55821885622e-11, 8e-09, 3.56508193489e-11, 8.2e-09, 3.57240846437e-11, 8.4e-09, 3.5802042777e-11, 8.6e-09, 3.58847527561e-11, 8.8e-09, 3.59722742832e-11, 9e-09, 3.60646677709e-11, 9.2e-09, 3.61619943549e-11, 9.4e-09, 3.62643159053e-11, 9.6e-09, 3.63716950338e-11, 9.8e-09, 3.64841950993e-11, 1e-08, 3.66018802096e-11, 1.02e-08, 3.67248152202e-11, 1.04e-08, 3.68530657291e-11, 1.06e-08, 3.69866980683e-11, 1.08e-08, 3.71257792914e-11, 1.1e-08, 3.7270377156e-11, 1.12e-08, 3.74205601025e-11, 1.14e-08, 3.75763972276e-11, 1.16e-08, 3.77379582525e-11, 1.18e-08, 3.79053134858e-11, 1.2e-08, 3.80785337803e-11, 1.22e-08, 3.82576904842e-11, 1.24e-08, 3.84428553845e-11, 1.26e-08, 3.86341006445e-11, 1.28e-08, 3.88314987337e-11, 1.3e-08, 3.9035122349e-11, 1.32e-08, 3.92450443286e-11, 1.34e-08, 3.94613375565e-11, 1.36e-08, 3.96840748582e-11, 1.38e-08, 3.99133288858e-11, 1.4e-08, 4.01491719935e-11, 1.42e-08, 4.0391676102e-11, 1.44e-08, 4.06409125513e-11, 1.46e-08, 4.08969519414e-11, 1.48e-08, 4.11598639608e-11, 1.5e-08, 4.14297172012e-11, 1.52e-08, 4.17065789589e-11, 1.54e-08, 4.19905150206e-11, 1.56e-08, 4.22815894357e-11, 1.58e-08, 4.25798642712e-11, 1.6e-08, 4.28853993512e-11, 1.62e-08, 4.31982519786e-11, 1.64e-08, 4.35184766399e-11, 1.66e-08, 4.38461246905e-11, 1.68e-08, 4.41812440225e-11, 1.7e-08, 4.45238787113e-11, 1.72e-08, 4.48740686441e-11, 1.74e-08, 4.52318491258e-11, 1.76e-08, 4.55972504659e-11, 1.78e-08, 4.59702975421e-11, 1.8e-08, 4.6351009344e-11, 1.82e-08, 4.67393984938e-11, 1.84e-08, 4.71354707453e-11, 1.86e-08, 4.75392244607e-11, 1.88e-08, 4.7950650066e-11, 1.9e-08, 4.83697294843e-11, 1.92e-08, 4.87964355479e-11, 1.94e-08, 4.92307313897e-11, 1.96e-08, 4.96725698155e-11, 1.98e-08, 5.01218926563e-11, 2e-08, 5.0578630104e-11, 2.02e-08, 5.10427000306e-11, 2.04e-08, 5.1514007293e-11, 2.06e-08, 5.19924430262e-11, 2.08e-08, 5.24778839264e-11, 2.1e-08, 5.29701915264e-11, 2.12e-08, 5.34692114685e-11, 2.14e-08, 5.39747727758e-11, 2.16e-08, 5.44866871274e-11, 2.18e-08, 5.50047481415e-11, 2.2e-08, 5.55287306706e-11, 2.22e-08, 5.60583901149e-11, 2.24e-08, 5.65934617581e-11, 2.26e-08, 5.71336601335e-11, 2.28e-08, 5.76786784245e-11, 2.3e-08, 5.82281879092e-11, 2.32e-08, 5.87818374528e-11, 2.34e-08, 5.93392530597e-11, 2.36e-08, 5.99000374887e-11, 2.38e-08, 6.04637699437e-11, 2.4e-08, 6.10300058448e-11, 2.42e-08, 6.15982766919e-11, 2.44e-08, 6.21680900258e-11, 2.46e-08, 6.27389294989e-11, 2.48e-08, 6.33102550623e-11, 2.5e-08, 6.38815032778e-11, 2.52e-08, 6.44520877638e-11, 2.54e-08, 6.50213997818e-11, 2.56e-08, 6.55888089718e-11, 2.58e-08, 6.61536642414e-11, 2.6e-08, 6.67152948153e-11, 2.62e-08, 6.72730114501e-11, 2.64e-08, 6.78261078155e-11, 2.66e-08, 6.8373862047e-11, 2.68e-08, 6.89155384678e-11, 2.7e-08, 6.94503894803e-11, 2.72e-08, 6.99776576247e-11, 2.74e-08, 7.04965777984e-11, 2.76e-08, 7.10063796311e-11, 2.78e-08, 7.15062900065e-11, 2.8e-08, 7.199553572e-11, 2.82e-08, 7.24733462586e-11, 2.84e-08, 7.29389566903e-11, 2.86e-08, 7.33916106446e-11, 2.88e-08, 7.38305633658e-11, 2.9e-08, 7.42550848187e-11, 2.92e-08, 7.46644628253e-11, 2.94e-08, 7.50580062081e-11, 2.96e-08, 7.54350479161e-11, 2.98e-08, 7.57949481077e-11, 3e-08, 7.61370971649e-11, 3.02e-08, 7.64609186127e-11, 3.04e-08, 7.67658719165e-11, 3.06e-08, 7.70514551336e-11, 3.08e-08, 7.73172073926e-11, 3.1e-08, 7.7562711178e-11, 3.12e-08, 7.77875943972e-11, 3.14e-08, 7.79915322116e-11, 3.16e-08, 7.81742486112e-11, 3.18e-08, 7.83355177205e-11, 3.2e-08, 7.84751648208e-11, 3.22e-08, 7.85930670799e-11, 3.24e-08, 7.86891539844e-11, 3.26e-08, 7.87634074679e-11, 3.28e-08, 7.88158617393e-11, 3.3e-08, 7.88466028104e-11, 3.32e-08, 7.88557677322e-11, 3.34e-08, 7.88435435473e-11, 3.36e-08, 7.88101659721e-11, 3.38e-08, 7.8755917823e-11, 3.4e-08, 7.86811272035e-11, 3.42e-08, 7.8586165473e-11, 3.44e-08, 7.84714450167e-11, 3.46e-08, 7.83374168411e-11, 3.48e-08, 7.81845680172e-11, 3.5e-08, 7.80134189964e-11, 3.52e-08, 7.78245208248e-11, 3.54e-08, 7.76184522794e-11, 3.56e-08, 7.73958169516e-11, 3.58e-08, 7.71572403016e-11, 3.6e-08, 7.69033667074e-11, 3.62e-08, 7.66348565301e-11, 3.64e-08, 7.63523832157e-11, 3.66e-08, 7.6056630454e-11, 3.68e-08, 7.57482894102e-11, 3.7e-08, 7.54280560472e-11, 3.72e-08, 7.50966285507e-11, 3.74e-08, 7.47547048708e-11, 3.76e-08, 7.44029803886e-11, 3.78e-08, 7.40421457184e-11, 3.8e-08, 7.36728846494e-11, 3.82e-08, 7.32958722351e-11, 3.84e-08, 7.29117730295e-11, 3.86e-08, 7.2521239476e-11, 3.88e-08, 7.21249104453e-11, 3.9e-08, 7.17234099245e-11, 3.92e-08, 7.13173458524e-11, 3.94e-08, 7.09073090992e-11, 3.96e-08, 7.04938725858e-11, 3.98e-08, 7.00775905377e-11, 4e-08, 6.96589978677e-11, 4.02e-08, 6.9238609681e-11, 4.04e-08, 6.88169208959e-11, 4.06e-08, 6.83944059736e-11, 4.08e-08, 6.79715187498e-11, 4.1e-08, 6.75486923595e-11, 4.12e-08, 6.71263392493e-11, 4.14e-08, 6.67048512693e-11, 4.16e-08, 6.6284599837e-11, 4.18e-08, 6.58659361659e-11, 4.2e-08, 6.54491915533e-11, 4.22e-08, 6.50346777192e-11, 4.24e-08, 6.4622687191e-11, 4.26e-08, 6.42134937268e-11, 4.28e-08, 6.38073527737e-11, 4.3e-08, 6.34045019536e-11, 4.32e-08, 6.30051615724e-11, 4.34e-08, 6.26095351483e-11, 4.36e-08, 6.22178099547e-11, 4.38e-08, 6.18301575731e-11, 4.4e-08, 6.14467344539e-11, 4.42e-08, 6.10676824799e-11, 4.44e-08, 6.06931295314e-11, 4.46e-08, 6.03231900489e-11, 4.48e-08, 5.99579655922e-11, 4.5e-08, 5.95975453926e-11, 4.52e-08, 5.92420068975e-11, 4.54e-08, 5.88914163053e-11, 4.56e-08, 5.8545829089e-11, 4.58e-08, 5.82052905082e-11, 4.6e-08, 5.78698361078e-11, 4.62e-08, 5.75394922031e-11, 4.64e-08, 5.72142763501e-11, 4.66e-08, 5.68941978016e-11, 4.68e-08, 5.65792579478e-11, 4.7e-08, 5.62694507415e-11, 4.72e-08, 5.59647631087e-11, 4.74e-08, 5.56651753424e-11, 4.76e-08, 5.53706614829e-11, 4.78e-08, 5.50811896814e-11, 4.8e-08, 5.47967225503e-11, 4.82e-08, 5.45172174975e-11, 4.84e-08, 5.42426270478e-11, 4.86e-08, 5.39728991501e-11, 4.88e-08, 5.37079774708e-11, 4.9e-08, 5.34478016752e-11, 4.92e-08, 5.31923076961e-11, 4.94e-08, 5.29414279903e-11, 4.96e-08, 5.26950917842e-11, 4.98e-08, 5.24532253086e-11, 5e-08, 5.22157520225e-11, 5.02e-08, 5.19825928281e-11, 5.04e-08, 5.17536662758e-11, 5.06e-08, 5.15288887609e-11, 5.08e-08, 5.13081747117e-11, 5.1e-08, 5.10914367706e-11, 5.12e-08, 5.08785859672e-11, 5.14e-08, 5.06695318849e-11, 5.16e-08, 5.04641828217e-11, 5.18e-08, 5.02624459444e-11, 5.2e-08, 5.00642274382e-11, 5.22e-08, 4.98694326507e-11, 5.24e-08, 4.96779662312e-11, 5.26e-08, 4.94897322669e-11, 5.28e-08, 4.93046344136e-11, 5.3e-08, 4.91225760243e-11, 5.32e-08, 4.89434602734e-11, 5.34e-08, 4.87671902789e-11, 5.36e-08, 4.85936692209e-11, 5.38e-08, 4.8422800459e-11, 5.4e-08, 4.82544876456e-11, 5.42e-08, 4.80886348389e-11, 5.44e-08, 4.79251466131e-11, 5.46e-08, 4.77639281663e-11, 5.48e-08, 4.76048854285e-11, 5.5e-08, 4.74479251657e-11, 5.52e-08, 4.72929550849e-11, 5.54e-08, 4.71398839355e-11, 5.56e-08, 4.69886216112e-11, 5.58e-08, 4.68390792486e-11, 5.6e-08, 4.66911693265e-11, 5.62e-08, 4.65448057614e-11, 5.64e-08, 4.63999040038e-11, 5.66e-08, 4.62563811309e-11, 5.68e-08, 4.61141559394e-11, 5.7e-08, 4.59731490348e-11, 5.72e-08, 4.58332829205e-11, 5.74e-08, 4.56944820835e-11, 5.76e-08, 4.55566730788e-11, 5.78e-08, 4.54197846108e-11, 5.8e-08, 4.52837476132e-11, 5.82e-08, 4.5148495325e-11, 5.84e-08, 4.50139633645e-11, 5.86e-08, 4.48800898001e-11, 5.88e-08, 4.47468152176e-11, 5.9e-08, 4.46140827846e-11, 5.92e-08, 4.44818383108e-11, 5.94e-08, 4.43500303048e-11, 5.96e-08, 4.42186100268e-11, 5.98e-08, 4.40875315375e-11, 6e-08, 4.39567517419e-11, 6.02e-08, 4.38262304298e-11, 6.04e-08, 4.36959303104e-11, 6.06e-08, 4.35658170432e-11, 6.08e-08, 4.34358592634e-11, 6.1e-08, 4.33060286025e-11, 6.12e-08, 4.31762997037e-11, 6.14e-08, 4.30466502322e-11, 6.16e-08, 4.29170608806e-11, 6.18e-08, 4.27875153681e-11, 6.2e-08, 4.26580004354e-11, 6.22e-08, 4.25285058337e-11, 6.24e-08, 4.23990243087e-11, 6.26e-08, 4.22695515793e-11, 6.28e-08, 4.21400863108e-11, 6.3e-08, 4.20106300832e-11, 6.32e-08, 4.18811873551e-11, 6.34e-08, 4.17517654214e-11, 6.36e-08, 4.16223743675e-11, 6.38e-08, 4.14930270182e-11, 6.4e-08, 4.13637388824e-11, 6.42e-08, 4.12345280939e-11, 6.44e-08, 4.11054153472e-11, 6.46e-08, 4.09764238309e-11, 6.48e-08, 4.08475791565e-11, 6.5e-08, 4.07189092846e-11, 6.52e-08, 4.05904444472e-11, 6.54e-08, 4.04622170687e-11, 6.56e-08, 4.0334261683e-11, 6.58e-08, 4.02066148491e-11, 6.6e-08, 4.0079315065e-11, 6.62e-08, 3.99524026796e-11, 6.64e-08, 3.98259198038e-11, 6.66e-08, 3.96999102199e-11, 6.68e-08, 3.95744192915e-11, 6.7e-08, 3.94494938716e-11, 6.72e-08, 3.93251822118e-11, 6.74e-08, 3.92015338712e-11, 6.76e-08, 3.90785996259e-11, 6.78e-08, 3.89564313791e-11, 6.8e-08, 3.88350820722e-11, 6.82e-08, 3.8714605598e-11, 6.84e-08, 3.85950567138e-11, 6.86e-08, 3.84764909579e-11, 6.88e-08, 3.83589645672e-11, 6.9e-08, 3.82425343968e-11, 6.92e-08, 3.81272578429e-11, 6.94e-08, 3.80131927668e-11, 6.96e-08, 3.79003974231e-11, 6.98e-08, 3.77889303898e-11, 7e-08, 3.76788505014e-11, 7.02e-08, 3.75702167855e-11, 7.04e-08, 3.74630884021e-11, 7.06e-08, 3.73575245868e-11, 7.08e-08, 3.72535845962e-11, 7.1e-08, 3.71513276584e-11, 7.12e-08, 3.70508129248e-11, 7.14e-08, 3.69520994274e-11, 7.16e-08, 3.68552460382e-11, 7.18e-08, 3.67603114323e-11, 7.2e-08, 3.66673540552e-11, 7.22e-08, 3.65764320925e-11, 7.24e-08, 3.64876034436e-11, 7.26e-08, 3.64009256989e-11, 7.28e-08, 3.63164561196e-11, 7.3e-08, 3.62342516217e-11, 7.32e-08, 3.6154368762e-11, 7.34e-08, 3.60768637288e-11, 7.36e-08, 3.60017923338e-11, 7.38e-08, 3.59292100085e-11, 7.4e-08, 3.58591718022e-11, 7.42e-08, 3.57917323841e-11, 7.44e-08, 3.57269460465e-11, 7.46e-08, 3.56648667117e-11, 7.48e-08, 3.56055479411e-11, 7.5e-08, 3.55490429461e-11, 7.52e-08, 3.54954046019e-11, 7.54e-08, 3.54446854627e-11, 7.56e-08, 3.53969377799e-11, 7.58e-08, 3.5352213521e-11, 7.6e-08, 3.53105643909e-11, 7.62e-08, 3.52720418551e-11, 7.64e-08, 3.52366971634e-11, 7.66e-08, 3.52045813764e-11, 7.68e-08, 3.51757453921e-11, 7.7e-08, 3.51502399743e-11, 7.72e-08, 3.5128115782e-11, 7.74e-08, 3.51094233996e-11, 7.76e-08, 3.5094213368e-11, 7.78e-08, 3.50825362166e-11, 7.8e-08, 3.50744424961e-11, 7.82e-08, 3.50699828108e-11, 7.84e-08, 3.50692078529e-11, 7.86e-08, 3.50721684357e-11, 7.88e-08, 3.50789155281e-11, 7.9e-08, 3.50895002884e-11, 7.92e-08, 3.51039740984e-11, 7.94e-08, 3.51223885978e-11, 7.96e-08, 3.51447957175e-11, 7.98e-08, 3.51712477138e-11, 8e-08, 3.52017972007e-11, 8.02e-08, 3.52364971833e-11, 8.04e-08, 3.52754010891e-11, 8.06e-08, 3.53185627997e-11, 8.08e-08, 3.5366036681e-11, 8.1e-08, 3.54178776127e-11, 8.12e-08, 3.54741410162e-11, 8.14e-08, 3.55348828825e-11, 8.16e-08, 3.56001597973e-11, 8.18e-08, 3.56700289657e-11, 8.2e-08, 3.57445482349e-11, 8.22e-08, 3.58237761149e-11, 8.24e-08, 3.59077717982e-11, 8.26e-08, 3.59965951761e-11, 8.28e-08, 3.6090306854e-11, 8.3e-08, 3.61889681641e-11, 8.32e-08, 3.62926411747e-11, 8.34e-08, 3.64013886977e-11, 8.36e-08, 3.65152742932e-11, 8.38e-08, 3.66343622697e-11, 8.4e-08, 3.67587176828e-11, 8.42e-08, 3.68884063285e-11, 8.44e-08, 3.70234947339e-11, 8.46e-08, 3.71640501435e-11, 8.48e-08, 3.73101405006e-11, 8.5e-08, 3.74618344243e-11, 8.52e-08, 3.76192011825e-11, 8.54e-08, 3.77823106579e-11, 8.56e-08, 3.79512333097e-11, 8.58e-08, 3.81260401288e-11, 8.6e-08, 3.83068025868e-11, 8.62e-08, 3.84935925783e-11, 8.64e-08, 3.86864823562e-11, 8.66e-08, 3.88855444587e-11, 8.68e-08, 3.90908516297e-11, 8.7e-08, 3.93024767295e-11, 8.72e-08, 3.9520492637e-11, 8.74e-08, 3.97449721426e-11, 8.76e-08, 3.99759878314e-11, 8.78e-08, 4.02136119549e-11, 8.8e-08, 4.04579162929e-11, 8.82e-08, 4.07089720028e-11, 8.84e-08, 4.09668494574e-11, 8.86e-08, 4.12316180696e-11, 8.88e-08, 4.15033461033e-11, 8.9e-08, 4.17821004713e-11, 8.92e-08, 4.2067946517e-11, 8.94e-08, 4.23609477823e-11, 8.96e-08, 4.26611657584e-11, 8.98e-08, 4.29686596207e-11, 9e-08, 4.32834859459e-11, 9.02e-08, 4.36056984115e-11, 9.04e-08, 4.39353474768e-11, 9.06e-08, 4.42724800447e-11, 9.08e-08, 4.4617139104e-11, 9.1e-08, 4.49693633509e-11, 9.12e-08, 4.53291867912e-11, 9.14e-08, 4.56966383198e-11, 9.16e-08, 4.60717412798e-11, 9.18e-08, 4.64545129993e-11, 9.2e-08, 4.6844964307e-11, 9.22e-08, 4.72430990246e-11, 9.24e-08, 4.76489134386e-11, 9.26e-08, 4.8062395749e-11, 9.28e-08, 4.8483525497e-11, 9.3e-08, 4.89122729719e-11, 9.32e-08, 4.9348598597e-11, 9.34e-08, 4.97924522962e-11, 9.36e-08, 5.02437728422e-11, 9.38e-08, 5.07024871873e-11, 9.4e-08, 5.11685097784e-11, 9.42e-08, 5.16417418589e-11, 9.44e-08, 5.21220707588e-11, 9.46e-08, 5.26093691749e-11, 9.48e-08, 5.31034944463e-11, 9.5e-08, 5.36042878252e-11, 9.52e-08, 5.41115737501e-11, 9.54e-08, 5.46251591217e-11, 9.56e-08, 5.51448325895e-11, 9.58e-08, 5.56703638508e-11, 9.6e-08, 5.62015029698e-11, 9.62e-08, 5.67379797211e-11, 9.64e-08, 5.7279502964e-11, 9.66e-08, 5.78257600545e-11, 9.68e-08, 5.83764163015e-11, 9.7e-08, 5.89311144754e-11, 9.72e-08, 5.94894743751e-11, 9.74e-08, 6.00510924637e-11, 9.76e-08, 6.06155415795e-11, 9.78e-08, 6.11823707311e-11, 9.8e-08, 6.17511049861e-11, 9.82e-08, 6.23212454614e-11, 9.84e-08, 6.28922694236e-11, 9.86e-08, 6.34636305092e-11, 9.88e-08, 6.40347590716e-11, 9.9e-08, 6.46050626642e-11, 9.92e-08, 6.51739266662e-11, 9.94e-08, 6.57407150581e-11, 9.96e-08, 6.63047713542e-11, 9.98e-08, 6.68654196955e-11, 1e-07, 6.74219661092e-11, 1.002e-07, 6.79736999355e-11, 1.004e-07, 6.85198954261e-11, 1.006e-07, 6.90598135114e-11, 1.008e-07, 6.95927037376e-11, 1.01e-07, 7.01178063687e-11, 1.012e-07, 7.06343546486e-11, 1.014e-07, 7.11415772165e-11, 1.016e-07, 7.16387006661e-11, 1.018e-07, 7.21249522374e-11, 1.02e-07, 7.25995626279e-11, 1.022e-07, 7.30617689078e-11, 1.024e-07, 7.3510817522e-11, 1.026e-07, 7.39459673596e-11, 1.028e-07, 7.43664928704e-11, 1.03e-07, 7.47716872052e-11, 1.032e-07, 7.51608653574e-11, 1.034e-07, 7.55333672797e-11, 1.036e-07, 7.5888560951e-11, 1.038e-07, 7.62258453682e-11, 1.04e-07, 7.65446534347e-11, 1.042e-07, 7.68444547221e-11, 1.044e-07, 7.71247580767e-11, 1.046e-07, 7.73851140498e-11, 1.048e-07, 7.76251171255e-11, 1.05e-07, 7.78444077265e-11, 1.052e-07, 7.80426739779e-11, 1.054e-07, 7.82196532111e-11, 1.056e-07, 7.83751331944e-11, 1.058e-07, 7.8508953078e-11, 1.06e-07, 7.86210040441e-11, 1.062e-07, 7.87112296579e-11, 1.064e-07, 7.8779625915e-11, 1.066e-07, 7.88262409888e-11, 1.068e-07, 7.88511746788e-11, 1.07e-07, 7.88545775699e-11, 1.072e-07, 7.88366499108e-11, 1.074e-07, 7.87976402261e-11, 1.076e-07, 7.87378436763e-11, 1.078e-07, 7.86576001845e-11, 1.08e-07, 7.85572923495e-11, 1.082e-07, 7.84373431669e-11, 1.084e-07, 7.82982135808e-11, 1.086e-07, 7.81403998909e-11, 1.088e-07, 7.79644310388e-11, 1.09e-07, 7.77708657983e-11, 1.092e-07, 7.75602898954e-11, 1.094e-07, 7.73333130818e-11, 1.096e-07, 7.70905661854e-11, 1.098e-07, 7.68326981617e-11, 1.1e-07, 7.65603731667e-11, 1.102e-07, 7.62742676726e-11, 1.104e-07, 7.5975067644e-11, 1.106e-07, 7.56634657931e-11, 1.108e-07, 7.53401589275e-11, 1.11e-07, 7.50058454061e-11, 1.112e-07, 7.46612227129e-11, 1.114e-07, 7.43069851598e-11, 1.116e-07, 7.39438217247e-11, 1.118e-07, 7.35724140336e-11, 1.12e-07, 7.31934344883e-11, 1.122e-07, 7.28075445439e-11, 1.124e-07, 7.24153931376e-11, 1.126e-07, 7.20176152676e-11, 1.128e-07, 7.16148307212e-11, 1.13e-07, 7.12076429495e-11, 1.132e-07, 7.07966380855e-11, 1.134e-07, 7.03823840992e-11, 1.136e-07, 6.99654300874e-11, 1.138e-07, 6.95463056895e-11, 1.14e-07, 6.91255206242e-11, 1.142e-07, 6.87035643408e-11, 1.144e-07, 6.82809057762e-11, 1.146e-07, 6.7857993213e-11, 1.148e-07, 6.74352542278e-11, 1.15e-07, 6.70130957266e-11, 1.152e-07, 6.65919040555e-11, 1.154e-07, 6.61720451834e-11, 1.156e-07, 6.57538649472e-11, 1.158e-07, 6.53376893537e-11, 1.16e-07, 6.49238249313e-11, 1.162e-07, 6.45125591259e-11, 1.164e-07, 6.41041607342e-11, 1.166e-07, 6.36988803695e-11, 1.168e-07, 6.32969509545e-11, 1.17e-07, 6.28985882362e-11, 1.172e-07, 6.25039913183e-11, 1.174e-07, 6.21133432073e-11, 1.176e-07, 6.17268113676e-11, 1.178e-07, 6.13445482838e-11, 1.18e-07, 6.09666920244e-11, 1.182e-07, 6.05933668068e-11, 1.184e-07, 6.02246835593e-11, 1.186e-07, 5.98607404783e-11, 1.188e-07, 5.95016235789e-11, 1.19e-07, 5.91474072365e-11, 1.192e-07, 5.87981547197e-11, 1.194e-07, 5.84539187099e-11, 1.196e-07, 5.81147418108e-11, 1.198e-07, 5.77806570425e-11, 1.2e-07, 5.74516883234e-11, 1.202e-07, 5.71278509365e-11, 1.204e-07, 5.68091519814e-11, 1.206e-07, 5.64955908107e-11, 1.208e-07, 5.61871594513e-11, 1.21e-07, 5.58838430104e-11, 1.212e-07, 5.55856200662e-11, 1.214e-07, 5.52924630428e-11, 1.216e-07, 5.5004338571e-11, 1.218e-07, 5.47212078336e-11, 1.22e-07, 5.4443026897e-11, 1.222e-07, 5.4169747028e-11, 1.224e-07, 5.39013149975e-11, 1.226e-07, 5.36376733709e-11, 1.228e-07, 5.33787607856e-11, 1.23e-07, 5.31245122167e-11, 1.232e-07, 5.28748592301e-11, 1.234e-07, 5.26297302255e-11, 1.236e-07, 5.23890506681e-11, 1.238e-07, 5.21527433098e-11, 1.24e-07, 5.19207284018e-11, 1.242e-07, 5.16929238969e-11, 1.244e-07, 5.14692456444e-11, 1.246e-07, 5.12496075757e-11, 1.248e-07, 5.10339218834e-11, 1.25e-07, 5.08220991929e-11, 1.252e-07, 5.06140487271e-11, 1.254e-07, 5.04096784654e-11, 1.256e-07, 5.02088952965e-11, 1.258e-07, 5.0011605167e-11, 1.26e-07, 4.98177132233e-11, 1.262e-07, 4.96271239509e-11, 1.264e-07, 4.94397413083e-11, 1.266e-07, 4.92554688576e-11, 1.268e-07, 4.90742098918e-11, 1.27e-07, 4.88958675583e-11, 1.272e-07, 4.87203449802e-11, 1.274e-07, 4.85475453745e-11, 1.276e-07, 4.8377372168e-11, 1.278e-07, 4.82097291114e-11, 1.28e-07, 4.80445203906e-11, 1.282e-07, 4.78816507365e-11, 1.284e-07, 4.77210255335e-11, 1.286e-07, 4.75625509254e-11, 1.288e-07, 4.7406133921e-11, 1.29e-07, 4.7251682497e-11, 1.292e-07, 4.70991057001e-11, 1.294e-07, 4.69483137478e-11, 1.296e-07, 4.67992181277e-11, 1.298e-07, 4.66517316948e-11, 1.3e-07, 4.65057687683e-11, 1.302e-07, 4.63612452262e-11, 1.304e-07, 4.62180785982e-11, 1.306e-07, 4.60761881579e-11, 1.308e-07, 4.59354950117e-11, 1.31e-07, 4.5795922187e-11, 1.312e-07, 4.56573947178e-11, 1.314e-07, 4.55198397281e-11, 1.316e-07, 4.53831865132e-11, 1.318e-07, 4.5247366618e-11, 1.32e-07, 4.51123139132e-11, 1.322e-07, 4.4977964668e-11, 1.324e-07, 4.484425762e-11, 1.326e-07, 4.4711134042e-11, 1.328e-07, 4.45785378049e-11, 1.33e-07, 4.44464154376e-11, 1.332e-07, 4.43147161823e-11, 1.334e-07, 4.41833920463e-11, 1.336e-07, 4.40523978497e-11, 1.338e-07, 4.39216912681e-11, 1.34e-07, 4.37912328718e-11, 1.342e-07, 4.36609861591e-11, 1.344e-07, 4.3530917586e-11, 1.346e-07, 4.34009965903e-11, 1.348e-07, 4.32711956105e-11, 1.35e-07, 4.31414901003e-11, 1.352e-07, 4.30118585373e-11, 1.354e-07, 4.28822824267e-11, 1.356e-07, 4.27527462996e-11, 1.358e-07, 4.26232377061e-11, 1.36e-07, 4.24937472032e-11, 1.362e-07, 4.23642683368e-11, 1.364e-07, 4.22347976196e-11, 1.366e-07, 4.21053345026e-11, 1.368e-07, 4.19758813425e-11, 1.37e-07, 4.18464433633e-11, 1.372e-07, 4.17170286139e-11, 1.374e-07, 4.15876479202e-11, 1.376e-07, 4.14583148331e-11, 1.378e-07, 4.13290455722e-11, 1.38e-07, 4.11998589649e-11, 1.382e-07, 4.10707763821e-11, 1.384e-07, 4.09418216699e-11, 1.386e-07, 4.08130210778e-11, 1.388e-07, 4.06844031836e-11, 1.39e-07, 4.05559988162e-11, 1.392e-07, 4.0427840974e-11, 1.394e-07, 4.02999647431e-11, 1.396e-07, 4.01724072115e-11, 1.398e-07, 4.00452073828e-11, 1.4e-07, 3.99184060877e-11, 1.402e-07, 3.97920458945e-11, 1.404e-07, 3.96661710191e-11, 1.406e-07, 3.95408272336e-11, 1.408e-07, 3.94160617757e-11, 1.41e-07, 3.92919232567e-11, 1.412e-07, 3.91684615714e-11, 1.414e-07, 3.9045727807e-11, 1.416e-07, 3.89237741543e-11, 1.418e-07, 3.88026538186e-11, 1.42e-07, 3.86824209329e-11, 1.422e-07, 3.85631304726e-11, 1.424e-07, 3.84448381714e-11, 1.426e-07, 3.83276004399e-11, 1.428e-07, 3.82114742861e-11, 1.43e-07, 3.80965172381e-11, 1.432e-07, 3.798278727e-11, 1.434e-07, 3.78703427299e-11, 1.436e-07, 3.7759242271e-11, 1.438e-07, 3.76495447858e-11, 1.44e-07, 3.75413093432e-11, 1.442e-07, 3.7434595129e-11, 1.444e-07, 3.73294613895e-11, 1.446e-07, 3.72259673787e-11, 1.448e-07, 3.71241723084e-11, 1.45e-07, 3.70241353021e-11, 1.452e-07, 3.69259153528e-11, 1.454e-07, 3.68295712829e-11, 1.456e-07, 3.67351617091e-11, 1.458e-07, 3.66427450099e-11, 1.46e-07, 3.65523792965e-11, 1.462e-07, 3.64641223876e-11, 1.464e-07, 3.63780317869e-11, 1.466e-07, 3.62941646645e-11, 1.468e-07, 3.6212577841e-11, 1.47e-07, 3.61333277754e-11, 1.472e-07, 3.60564705553e-11, 1.474e-07, 3.59820618908e-11, 1.476e-07, 3.59101571106e-11, 1.478e-07, 3.5840811162e-11, 1.48e-07, 3.57740786123e-11, 1.482e-07, 3.57100136538e-11, 1.484e-07, 3.56486701111e-11, 1.486e-07, 3.55901014502e-11, 1.488e-07, 3.5534360791e-11, 1.49e-07, 3.54815009208e-11, 1.492e-07, 3.54315743108e-11, 1.494e-07, 3.53846331342e-11, 1.496e-07, 3.53407292859e-11, 1.498e-07, 3.52999144041e-11, 1.5e-07, 3.5262239894e-11, 1.502e-07, 3.52277569521e-11, 1.504e-07, 3.51965165926e-11, 1.506e-07, 3.51685696746e-11, 1.508e-07, 3.51439669309e-11, 1.51e-07, 3.51227589974e-11, 1.512e-07, 3.51049964438e-11, 1.514e-07, 3.50907298048e-11, 1.516e-07, 3.50800096122e-11, 1.518e-07, 3.50728864278e-11, 1.52e-07, 3.50694108763e-11, 1.522e-07, 3.50696336789e-11, 1.524e-07, 3.50736056876e-11, 1.526e-07, 3.50813779186e-11, 1.528e-07, 3.50930015868e-11, 1.53e-07, 3.51085281401e-11, 1.532e-07, 3.51280092928e-11, 1.534e-07, 3.51514970601e-11, 1.536e-07, 3.5179043791e-11, 1.538e-07, 3.52107022012e-11, 1.54e-07, 3.52465254063e-11, 1.542e-07, 3.52865669525e-11, 1.544e-07, 3.53308808485e-11, 1.546e-07, 3.53795215953e-11, 1.548e-07, 3.54325442152e-11, 1.55e-07, 3.549000428e-11, 1.552e-07, 3.55519579378e-11, 1.554e-07, 3.56184619382e-11, 1.556e-07, 3.56895736567e-11, 1.558e-07, 3.57653511162e-11, 1.56e-07, 3.58458530083e-11, 1.562e-07, 3.59311387112e-11, 1.564e-07, 3.60212683069e-11, 1.566e-07, 3.61163025946e-11, 1.568e-07, 3.62163031032e-11, 1.57e-07, 3.63213321001e-11, 1.572e-07, 3.64314525977e-11, 1.574e-07, 3.65467283571e-11, 1.576e-07, 3.66672238876e-11, 1.578e-07, 3.67930044444e-11, 1.58e-07, 3.69241360208e-11, 1.582e-07, 3.70606853381e-11, 1.584e-07, 3.72027198302e-11, 1.586e-07, 3.73503076244e-11, 1.588e-07, 3.75035175169e-11, 1.59e-07, 3.76624189441e-11, 1.592e-07, 3.78270819474e-11, 1.594e-07, 3.79975771334e-11, 1.596e-07, 3.81739756274e-11, 1.598e-07, 3.83563490206e-11, 1.6e-07, 3.85447693102e-11, 1.602e-07, 3.87393088332e-11, 1.604e-07, 3.89400401914e-11, 1.606e-07, 3.91470361689e-11, 1.608e-07, 3.9360369641e-11, 1.61e-07, 3.95801134738e-11, 1.612e-07, 3.98063404145e-11, 1.614e-07, 4.00391229715e-11, 1.616e-07, 4.0278533284e-11, 1.618e-07, 4.05246429798e-11, 1.62e-07, 4.07775230222e-11, 1.622e-07, 4.10372435442e-11, 1.624e-07, 4.13038736692e-11, 1.626e-07, 4.15774813191e-11, 1.628e-07, 4.18581330072e-11, 1.63e-07, 4.2145893617e-11, 1.632e-07, 4.24408261649e-11, 1.634e-07, 4.27429915473e-11, 1.636e-07, 4.30524482705e-11, 1.638e-07, 4.33692521631e-11, 1.64e-07, 4.3693456071e-11, 1.642e-07, 4.40251095326e-11, 1.644e-07, 4.43642584363e-11, 1.646e-07, 4.47109446565e-11, 1.648e-07, 4.50652056704e-11, 1.65e-07, 4.54270741538e-11, 1.652e-07, 4.57965775556e-11, 1.654e-07, 4.61737376507e-11, 1.656e-07, 4.65585700709e-11, 1.658e-07, 4.69510838147e-11, 1.66e-07, 4.73512807341e-11, 1.662e-07, 4.77591549996e-11, 1.664e-07, 4.8174692544e-11, 1.666e-07, 4.85978704842e-11, 1.668e-07, 4.90286565222e-11, 1.67e-07, 4.94670083258e-11, 1.672e-07, 4.99128728903e-11, 1.674e-07, 5.03661858816e-11, 1.676e-07, 5.08268709631e-11, 1.678e-07, 5.12948391065e-11, 1.68e-07, 5.17699878905e-11, 1.682e-07, 5.22522007877e-11, 1.684e-07, 5.2741346444e-11, 1.686e-07, 5.32372779516e-11, 1.688e-07, 5.37398321208e-11, 1.69e-07, 5.42488287528e-11, 1.692e-07, 5.47640699189e-11, 1.694e-07, 5.52853392489e-11, 1.696e-07, 5.58124012361e-11, 1.698e-07, 5.63450005615e-11, 1.7e-07, 5.68828614451e-11, 1.702e-07, 5.742568703e-11, 1.704e-07, 5.79731588054e-11, 1.706e-07, 5.85249360759e-11, 1.708e-07, 5.90806554854e-11, 1.71e-07, 5.96399306014e-11, 1.712e-07, 6.02023515703e-11, 1.714e-07, 6.076748485e-11, 1.716e-07, 6.13348730292e-11, 1.718e-07, 6.19040347431e-11, 1.72e-07, 6.24744646913e-11, 1.722e-07, 6.30456337706e-11, 1.724e-07, 6.3616989328e-11, 1.726e-07, 6.41879555432e-11, 1.728e-07, 6.47579339498e-11, 1.73e-07, 6.53263041e-11, 1.732e-07, 6.58924243825e-11, 1.734e-07, 6.6455632997e-11, 1.736e-07, 6.70152490913e-11, 1.738e-07, 6.75705740661e-11, 1.74e-07, 6.81208930474e-11, 1.742e-07, 6.86654765302e-11, 1.744e-07, 6.9203582192e-11, 1.746e-07, 6.97344568741e-11, 1.748e-07, 7.02573387273e-11, 1.75e-07, 7.07714595164e-11, 1.752e-07, 7.12760470742e-11, 1.754e-07, 7.17703278986e-11, 1.756e-07, 7.22535298769e-11, 1.758e-07, 7.27248851273e-11, 1.76e-07, 7.31836329383e-11, 1.762e-07, 7.36290227918e-11, 1.764e-07, 7.40603174465e-11, 1.766e-07, 7.44767960634e-11, 1.768e-07, 7.48777573488e-11, 1.77e-07, 7.52625226915e-11, 1.772e-07, 7.5630439269e-11, 1.774e-07, 7.59808830967e-11, 1.776e-07, 7.63132619945e-11, 1.778e-07, 7.66270184436e-11, 1.78e-07, 7.69216323093e-11, 1.782e-07, 7.71966234025e-11, 1.784e-07, 7.74515538576e-11, 1.786e-07, 7.76860303034e-11, 1.788e-07, 7.78997058047e-11, 1.79e-07, 7.80922815589e-11, 1.792e-07, 7.82635083274e-11, 1.794e-07, 7.84131875905e-11, 1.796e-07, 7.85411724142e-11, 1.798e-07, 7.86473680204e-11, 1.8e-07, 7.87317320563e-11, 1.802e-07, 7.87942745615e-11, 1.804e-07, 7.88350576337e-11, 1.806e-07, 7.88541947997e-11, 1.808e-07, 7.88518500973e-11, 1.81e-07, 7.88282368814e-11, 1.812e-07, 7.87836163664e-11, 1.814e-07, 7.87182959218e-11, 1.816e-07, 7.86326271398e-11, 1.818e-07, 7.85270036944e-11, 1.82e-07, 7.84018590147e-11, 1.822e-07, 7.82576637956e-11, 1.824e-07, 7.80949233701e-11, 1.826e-07, 7.7914174967e-11, 1.828e-07, 7.77159848802e-11, 1.83e-07, 7.75009455739e-11, 1.832e-07, 7.72696727473e-11, 1.834e-07, 7.70228023834e-11, 1.836e-07, 7.67609878041e-11, 1.838e-07, 7.64848967526e-11, 1.84e-07, 7.61952085234e-11, 1.842e-07, 7.58926111584e-11, 1.844e-07, 7.55777987251e-11, 1.846e-07, 7.5251468693e-11, 1.848e-07, 7.49143194189e-11, 1.85e-07, 7.45670477555e-11, 1.852e-07, 7.4210346789e-11, 1.854e-07, 7.38449037163e-11, 1.856e-07, 7.34713978647e-11, 1.858e-07, 7.30904988604e-11, 1.86e-07, 7.27028649464e-11, 1.862e-07, 7.23091414513e-11, 1.864e-07, 7.1909959409e-11, 1.866e-07, 7.15059343259e-11, 1.868e-07, 7.10976650951e-11, 1.87e-07, 7.06857330511e-11, 1.872e-07, 7.02707011622e-11, 1.874e-07, 6.98531133542e-11, 1.876e-07, 6.94334939596e-11, 1.878e-07, 6.9012347286e-11, 1.88e-07, 6.85901572957e-11, 1.882e-07, 6.81673873916e-11, 1.884e-07, 6.7744480299e-11, 1.886e-07, 6.73218580394e-11, 1.888e-07, 6.68999219855e-11, 1.89e-07, 6.64790529929e-11, 1.892e-07, 6.60596115998e-11, 1.894e-07, 6.5641938288e-11, 1.896e-07, 6.52263537993e-11, 1.898e-07, 6.4813159499e-11, 1.9e-07, 6.44026377828e-11, 1.902e-07, 6.39950525196e-11, 1.904e-07, 6.35906495244e-11, 1.906e-07, 6.31896570579e-11, 1.908e-07, 6.27922863465e-11, 1.91e-07, 6.23987321188e-11, 1.912e-07, 6.20091731544e-11, 1.914e-07, 6.16237728413e-11, 1.916e-07, 6.12426797386e-11, 1.918e-07, 6.08660281416e-11, 1.92e-07, 6.04939386451e-11, 1.922e-07, 6.01265187055e-11, 1.924e-07, 5.97638631953e-11, 1.926e-07, 5.94060549523e-11, 1.928e-07, 5.90531653188e-11, 1.93e-07, 5.87052546706e-11, 1.932e-07, 5.83623729347e-11, 1.934e-07, 5.80245600939e-11, 1.936e-07, 5.76918466786e-11, 1.938e-07, 5.73642542438e-11, 1.94e-07, 5.70417958322e-11, 1.942e-07, 5.67244764215e-11, 1.944e-07, 5.64122933571e-11, 1.946e-07, 5.61052367692e-11, 1.948e-07, 5.58032899747e-11, 1.95e-07, 5.55064298634e-11, 1.952e-07, 5.52146272697e-11, 1.954e-07, 5.49278473285e-11, 1.956e-07, 5.46460498174e-11, 1.958e-07, 5.43691894837e-11, 1.96e-07, 5.4097216358e-11, 1.962e-07, 5.38300760546e-11, 1.964e-07, 5.35677100575e-11, 1.966e-07, 5.33100559956e-11, 1.968e-07, 5.30570479043e-11, 1.97e-07, 5.28086164762e-11, 1.972e-07, 5.25646893011e-11, 1.974e-07, 5.23251910943e-11, 1.976e-07, 5.20900439162e-11, 1.978e-07, 5.18591673813e-11, 1.98e-07, 5.1632478859e-11, 1.982e-07, 5.14098936659e-11, 1.984e-07, 5.11913252495e-11, 1.986e-07, 5.0976685365e-11, 1.988e-07, 5.07658842453e-11, 1.99e-07, 5.05588307643e-11, 1.992e-07, 5.03554325937e-11, 1.994e-07, 5.01555963552e-11, 1.996e-07, 4.99592277665e-11, 1.998e-07, 4.97662317834e-11, 2e-07, 4.95765127367e-11, 2.002e-07, 4.9389974466e-11, 2.004e-07, 4.92065204487e-11, 2.006e-07, 4.90260539268e-11, 2.008e-07, 4.88484780292e-11, 2.01e-07, 4.86736958929e-11, 2.012e-07, 4.85016107798e-11, 2.014e-07, 4.83321261927e-11, 2.016e-07, 4.81651459881e-11, 2.018e-07, 4.80005744875e-11, 2.02e-07, 4.78383165868e-11, 2.022e-07, 4.76782778637e-11, 2.024e-07, 4.75203646842e-11, 2.026e-07, 4.73644843066e-11, 2.028e-07, 4.72105449848e-11, 2.03e-07, 4.70584560702e-11, 2.032e-07, 4.69081281115e-11, 2.034e-07, 4.67594729537e-11, 2.036e-07, 4.66124038356e-11, 2.038e-07, 4.64668354855e-11, 2.04e-07, 4.63226842156e-11, 2.042e-07, 4.61798680151e-11, 2.044e-07, 4.60383066406e-11, 2.046e-07, 4.58979217058e-11, 2.048e-07, 4.57586367683e-11, 2.05e-07, 4.56203774151e-11, 2.052e-07, 4.54830713452e-11, 2.054e-07, 4.53466484501e-11, 2.056e-07, 4.52110408918e-11, 2.058e-07, 4.50761831777e-11, 2.06e-07, 4.49420122329e-11, 2.062e-07, 4.48084674692e-11, 2.064e-07, 4.46754908508e-11, 2.066e-07, 4.45430269563e-11, 2.068e-07, 4.44110230377e-11, 2.07e-07, 4.42794290745e-11, 2.072e-07, 4.41481978247e-11, 2.074e-07, 4.40172848707e-11, 2.076e-07, 4.38866486618e-11, 2.078e-07, 4.37562505508e-11, 2.08e-07, 4.36260548276e-11, 2.082e-07, 4.34960287463e-11, 2.084e-07, 4.33661425485e-11, 2.086e-07, 4.3236369481e-11, 2.088e-07, 4.31066858085e-11, 2.09e-07, 4.29770708213e-11, 2.092e-07, 4.28475068371e-11, 2.094e-07, 4.27179791984e-11, 2.096e-07, 4.25884762638e-11, 2.098e-07, 4.24589893946e-11, 2.1e-07, 4.23295129357e-11, 2.102e-07, 4.22000441913e-11, 2.104e-07, 4.20705833959e-11, 2.106e-07, 4.19411336799e-11, 2.108e-07, 4.181170103e-11, 2.11e-07, 4.16822942453e-11, 2.112e-07, 4.15529248885e-11, 2.114e-07, 4.14236072327e-11, 2.116e-07, 4.12943582036e-11, 2.118e-07, 4.11651973179e-11, 2.12e-07, 4.10361466177e-11, 2.122e-07, 4.09072306015e-11, 2.124e-07, 4.07784761513e-11, 2.126e-07, 4.0649912457e-11, 2.128e-07, 4.05215709376e-11, 2.13e-07, 4.03934851605e-11, 2.132e-07, 4.02656907574e-11, 2.134e-07, 4.01382253392e-11, 2.136e-07, 4.00111284086e-11, 2.138e-07, 3.98844412716e-11, 2.14e-07, 3.97582069477e-11, 2.142e-07, 3.96324700794e-11, 2.144e-07, 3.95072768413e-11, 2.146e-07, 3.93826748487e-11, 2.148e-07, 3.92587130664e-11, 2.15e-07, 3.9135441718e-11, 2.152e-07, 3.90129121959e-11, 2.154e-07, 3.88911769717e-11, 2.156e-07, 3.87702895083e-11, 2.158e-07, 3.86503041731e-11, 2.16e-07, 3.85312761532e-11, 2.162e-07, 3.8413261372e-11, 2.164e-07, 3.82963164081e-11, 2.166e-07, 3.81804984165e-11, 2.168e-07, 3.80658650525e-11, 2.17e-07, 3.79524743972e-11, 2.172e-07, 3.78403848875e-11, 2.174e-07, 3.7729655247e-11, 2.176e-07, 3.76203444216e-11, 2.178e-07, 3.75125115175e-11, 2.18e-07, 3.74062157419e-11, 2.182e-07, 3.73015163484e-11, 2.184e-07, 3.71984725843e-11, 2.186e-07, 3.7097143642e-11, 2.188e-07, 3.69975886142e-11, 2.19e-07, 3.68998664517e-11, 2.192e-07, 3.68040359252e-11, 2.194e-07, 3.67101555903e-11, 2.196e-07, 3.66182837565e-11, 2.198e-07, 3.6528478459e-11, 2.2e-07, 3.64407974337e-11, 2.202e-07, 3.63552980967e-11, 2.204e-07, 3.62720375255e-11, 2.206e-07, 3.6191072445e-11, 2.208e-07, 3.6112459215e-11, 2.21e-07, 3.60362538225e-11, 2.212e-07, 3.59625118752e-11, 2.214e-07, 3.58912885997e-11, 2.216e-07, 3.58226388406e-11, 2.218e-07, 3.57566170643e-11, 2.22e-07, 3.56932773635e-11, 2.222e-07, 3.56326734654e-11, 2.224e-07, 3.55748587418e-11, 2.226e-07, 3.5519886222e-11, 2.228e-07, 3.54678086068e-11, 2.23e-07, 3.54186782854e-11, 2.232e-07, 3.53725473544e-11, 2.234e-07, 3.53294676374e-11, 2.236e-07, 3.5289490708e-11, 2.238e-07, 3.52526679127e-11, 2.24e-07, 3.52190503964e-11, 2.242e-07, 3.5188689129e-11, 2.244e-07, 3.51616349328e-11, 2.246e-07, 3.51379385118e-11, 2.248e-07, 3.51176504809e-11, 2.25e-07, 3.51008213974e-11, 2.252e-07, 3.5087501792e-11, 2.254e-07, 3.50777422013e-11, 2.256e-07, 3.50715932008e-11, 2.258e-07, 3.50691054377e-11, 2.26e-07, 3.50703296651e-11, 2.262e-07, 3.50753167756e-11, 2.264e-07, 3.50841178354e-11, 2.266e-07, 3.50967841186e-11, 2.268e-07, 3.51133671414e-11, 2.27e-07, 3.51339186954e-11, 2.272e-07, 3.51584908823e-11, 2.274e-07, 3.51871361461e-11, 2.276e-07, 3.5219907307e-11, 2.278e-07, 3.52568575928e-11, 2.28e-07, 3.5298040671e-11, 2.282e-07, 3.53435106795e-11, 2.284e-07, 3.53933222564e-11, 2.286e-07, 3.54475305688e-11, 2.288e-07, 3.55061913406e-11, 2.29e-07, 3.55693608791e-11, 2.292e-07, 3.56370960995e-11, 2.294e-07, 3.57094545488e-11, 2.296e-07, 3.57864944278e-11, 2.298e-07, 3.58682746104e-11, 2.3e-07, 3.59548546625e-11, 2.302e-07, 3.6046294857e-11, 2.304e-07, 3.6142656188e-11, 2.306e-07, 3.6244000382e-11, 2.308e-07, 3.63503899057e-11, 2.31e-07, 3.64618879724e-11, 2.312e-07, 3.65785585441e-11, 2.314e-07, 3.67004663309e-11, 2.316e-07, 3.68276767867e-11, 2.318e-07, 3.69602561018e-11, 2.32e-07, 3.70982711902e-11, 2.322e-07, 3.72417896741e-11, 2.324e-07, 3.7390879863e-11, 2.326e-07, 3.75456107279e-11, 2.328e-07, 3.77060518713e-11, 2.33e-07, 3.78722734905e-11, 2.332e-07, 3.80443463363e-11, 2.334e-07, 3.82223416643e-11, 2.336e-07, 3.84063311809e-11, 2.338e-07, 3.85963869815e-11, 2.34e-07, 3.87925814818e-11, 2.342e-07, 3.89949873408e-11, 2.344e-07, 3.92036773766e-11, 2.346e-07, 3.94187244722e-11, 2.348e-07, 3.96402014729e-11, 2.35e-07, 3.98681810742e-11, 2.352e-07, 4.01027356986e-11, 2.354e-07, 4.03439373622e-11, 2.356e-07, 4.05918575303e-11, 2.358e-07, 4.08465669599e-11, 2.36e-07, 4.11081355312e-11, 2.362e-07, 4.13766320646e-11, 2.364e-07, 4.16521241247e-11, 2.366e-07, 4.19346778097e-11, 2.368e-07, 4.22243575258e-11, 2.37e-07, 4.25212257459e-11, 2.372e-07, 4.28253427521e-11, 2.374e-07, 4.31367663607e-11, 2.376e-07, 4.34555516305e-11, 2.378e-07, 4.37817505521e-11, 2.38e-07, 4.41154117188e-11, 2.382e-07, 4.44565799778e-11, 2.384e-07, 4.48052960617e-11, 2.386e-07, 4.51615961995e-11, 2.388e-07, 4.55255117065e-11, 2.39e-07, 4.58970685532e-11, 2.392e-07, 4.62762869124e-11, 2.394e-07, 4.66631806846e-11, 2.396e-07, 4.70577570011e-11, 2.398e-07, 4.74600157052e-11, 2.4e-07, 4.78699488117e-11, 2.402e-07, 4.82875399447e-11, 2.404e-07, 4.87127637532e-11, 2.406e-07, 4.91455853074e-11, 2.408e-07, 4.95859594737e-11, 2.41e-07, 5.00338302714e-11, 2.412e-07, 5.04891302112e-11, 2.414e-07, 5.09517796179e-11, 2.416e-07, 5.14216859372e-11, 2.418e-07, 5.18987430319e-11, 2.42e-07, 5.23828304654e-11, 2.422e-07, 5.28738127801e-11, 2.424e-07, 5.33715387688e-11, 2.426e-07, 5.38758407474e-11, 2.428e-07, 5.43865338282e-11, 2.43e-07, 5.49034152013e-11, 2.432e-07, 5.54262634272e-11, 2.434e-07, 5.59548377461e-11, 2.436e-07, 5.6488877409e-11, 2.438e-07, 5.70281010371e-11, 2.44e-07, 5.75722060157e-11, 2.442e-07, 5.81208679288e-11, 2.444e-07, 5.86737400424e-11, 2.446e-07, 5.92304528438e-11, 2.448e-07, 5.97906136443e-11, 2.45e-07, 6.03538062542e-11, 2.452e-07, 6.09195907379e-11, 2.454e-07, 6.14875032585e-11, 2.456e-07, 6.20570560194e-11, 2.458e-07, 6.26277373129e-11, 2.46e-07, 6.31990116841e-11, 2.462e-07, 6.37703202178e-11, 2.464e-07, 6.43410809578e-11, 2.466e-07, 6.49106894653e-11, 2.468e-07, 6.54785195251e-11, 2.47e-07, 6.60439240037e-11, 2.472e-07, 6.66062358682e-11, 2.474e-07, 6.71647693676e-11, 2.476e-07, 6.77188213818e-11, 2.478e-07, 6.82676729411e-11, 2.48e-07, 6.88105909147e-11, 2.482e-07, 6.93468298698e-11, 2.484e-07, 6.98756340974e-11, 2.486e-07, 7.03962398015e-11, 2.488e-07, 7.09078774442e-11, 2.49e-07, 7.14097742396e-11, 2.492e-07, 7.19011567859e-11, 2.494e-07, 7.23812538227e-11, 2.496e-07, 7.28492991005e-11, 2.498e-07, 7.33045343446e-11, 2.5e-07, 7.37462122957e-11, 2.502e-07, 7.41735998076e-11, 2.504e-07, 7.45859809791e-11, 2.506e-07, 7.49826602982e-11, 2.508e-07, 7.53629657731e-11, 2.51e-07, 7.57262520261e-11, 2.512e-07, 7.60719033229e-11, 2.514e-07, 7.63993365123e-11, 2.516e-07, 7.67080038497e-11, 2.518e-07, 7.69973956789e-11, 2.52e-07, 7.72670429467e-11, 2.522e-07, 7.75165195276e-11, 2.524e-07, 7.77454443344e-11, 2.526e-07, 7.79534831968e-11, 2.528e-07, 7.81403504877e-11, 2.53e-07, 7.83058104816e-11, 2.532e-07, 7.84496784335e-11, 2.534e-07, 7.85718213663e-11, 2.536e-07, 7.86721585609e-11, 2.538e-07, 7.87506617444e-11, 2.54e-07, 7.88073549757e-11, 2.542e-07, 7.8842314232e-11, 2.544e-07, 7.88556667009e-11, 2.546e-07, 7.88475897872e-11, 2.548e-07, 7.88183098467e-11, 2.55e-07, 7.87681006606e-11, 2.552e-07, 7.86972816683e-11, 2.554e-07, 7.86062159765e-11, 2.556e-07, 7.84953081666e-11, 2.558e-07, 7.83650019218e-11, 2.56e-07, 7.82157774985e-11, 2.562e-07, 7.80481490649e-11, 2.564e-07, 7.78626619331e-11, 2.566e-07, 7.76598897083e-11, 2.568e-07, 7.74404313812e-11, 2.57e-07, 7.72049083857e-11, 2.572e-07, 7.69539616479e-11, 2.574e-07, 7.66882486454e-11, 2.576e-07, 7.64084405017e-11, 2.578e-07, 7.61152191317e-11, 2.58e-07, 7.58092744581e-11, 2.582e-07, 7.54913017149e-11, 2.584e-07, 7.51619988519e-11, 2.586e-07, 7.48220640517e-11, 2.588e-07, 7.44721933723e-11, 2.59e-07, 7.41130785218e-11, 2.592e-07, 7.37454047727e-11, 2.594e-07, 7.33698490221e-11, 2.596e-07, 7.29870779992e-11, 2.598e-07, 7.25977466244e-11, 2.6e-07, 7.22024965186e-11, 2.602e-07, 7.18019546622e-11, 2.604e-07, 7.1396732203e-11, 2.606e-07, 7.09874234074e-11, 2.608e-07, 7.05746047537e-11, 2.61e-07, 7.01588341595e-11, 2.612e-07, 6.97406503401e-11, 2.614e-07, 6.93205722902e-11, 2.616e-07, 6.88990988828e-11, 2.618e-07, 6.84767085784e-11, 2.62e-07, 6.80538592368e-11, 2.622e-07, 6.76309880248e-11, 2.624e-07, 6.72085114121e-11, 2.626e-07, 6.67868252482e-11, 2.628e-07, 6.63663049124e-11, 2.63e-07, 6.5947305531e-11, 2.632e-07, 6.55301622537e-11, 2.634e-07, 6.51151905833e-11, 2.636e-07, 6.47026867515e-11, 2.638e-07, 6.42929281359e-11, 2.64e-07, 6.38861737114e-11, 2.642e-07, 6.34826645307e-11, 2.644e-07, 6.30826242303e-11, 2.646e-07, 6.26862595546e-11, 2.648e-07, 6.22937608966e-11, 2.65e-07, 6.19053028491e-11, 2.652e-07, 6.15210447643e-11, 2.654e-07, 6.11411313167e-11, 2.656e-07, 6.07656930687e-11, 2.658e-07, 6.03948470334e-11, 2.66e-07, 6.00286972349e-11, 2.662e-07, 5.96673352616e-11, 2.664e-07, 5.9310840813e-11, 2.666e-07, 5.8959282236e-11, 2.668e-07, 5.86127170513e-11, 2.67e-07, 5.82711924675e-11, 2.672e-07, 5.79347458823e-11, 2.674e-07, 5.76034053707e-11, 2.676e-07, 5.72771901576e-11, 2.678e-07, 5.69561110776e-11, 2.68e-07, 5.66401710177e-11, 2.682e-07, 5.63293653461e-11, 2.684e-07, 5.60236823254e-11, 2.686e-07, 5.57231035099e-11, 2.688e-07, 5.54276041279e-11, 2.69e-07, 5.51371534497e-11, 2.692e-07, 5.4851715139e-11, 2.694e-07, 5.45712475915e-11, 2.696e-07, 5.42957042583e-11, 2.698e-07, 5.40250339556e-11, 2.7e-07, 5.37591811611e-11, 2.702e-07, 5.34980862978e-11, 2.704e-07, 5.32416860045e-11, 2.706e-07, 5.29899133952e-11, 2.708e-07, 5.27426983067e-11, 2.71e-07, 5.24999675349e-11, 2.712e-07, 5.22616450614e-11, 2.714e-07, 5.20276522699e-11, 2.716e-07, 5.17979081528e-11, 2.718e-07, 5.157232951e-11, 2.72e-07, 5.13508311386e-11, 2.722e-07, 5.11333260147e-11, 2.724e-07, 5.09197254686e-11, 2.726e-07, 5.07099393525e-11, 2.728e-07, 5.05038762024e-11, 2.73e-07, 5.03014433936e-11, 2.732e-07, 5.01025472907e-11, 2.734e-07, 4.99070933934e-11, 2.736e-07, 4.97149864763e-11, 2.738e-07, 4.95261307255e-11, 2.74e-07, 4.93404298707e-11, 2.742e-07, 4.9157787314e-11, 2.744e-07, 4.89781062548e-11, 2.746e-07, 4.88012898128e-11, 2.748e-07, 4.86272411468e-11, 2.75e-07, 4.84558635724e-11, 2.752e-07, 4.82870606761e-11, 2.754e-07, 4.81207364284e-11, 2.756e-07, 4.79567952945e-11, 2.758e-07, 4.77951423426e-11, 2.76e-07, 4.76356833519e-11, 2.762e-07, 4.74783249175e-11, 2.764e-07, 4.7322974555e-11, 2.766e-07, 4.7169540803e-11, 2.768e-07, 4.70179333244e-11, 2.77e-07, 4.68680630064e-11, 2.772e-07, 4.67198420586e-11, 2.774e-07, 4.65731841102e-11, 2.776e-07, 4.64280043055e-11, 2.778e-07, 4.62842193979e-11, 2.78e-07, 4.61417478422e-11, 2.782e-07, 4.60005098846e-11, 2.784e-07, 4.58604276524e-11, 2.786e-07, 4.57214252396e-11, 2.788e-07, 4.5583428792e-11, 2.79e-07, 4.54463665896e-11, 2.792e-07, 4.53101691256e-11, 2.794e-07, 4.51747691845e-11, 2.796e-07, 4.50401019157e-11, 2.798e-07, 4.49061049051e-11, 2.8e-07, 4.47727182434e-11, 2.802e-07, 4.46398845906e-11, 2.804e-07, 4.45075492375e-11, 2.806e-07, 4.43756601629e-11, 2.808e-07, 4.42441680875e-11, 2.81e-07, 4.41130265229e-11, 2.812e-07, 4.39821918174e-11, 2.814e-07, 4.3851623196e-11, 2.816e-07, 4.3721282797e-11, 2.818e-07, 4.35911357035e-11, 2.82e-07, 4.34611499696e-11, 2.822e-07, 4.33312966418e-11, 2.824e-07, 4.32015497763e-11, 2.826e-07, 4.30718864492e-11, 2.828e-07, 4.29422867636e-11, 2.83e-07, 4.28127338496e-11, 2.832e-07, 4.26832138605e-11, 2.834e-07, 4.25537159625e-11, 2.836e-07, 4.24242323197e-11, 2.838e-07, 4.22947580741e-11, 2.84e-07, 4.21652913196e-11, 2.842e-07, 4.20358330717e-11, 2.844e-07, 4.19063872314e-11, 2.846e-07, 4.1776960545e-11, 2.848e-07, 4.16475625585e-11, 2.85e-07, 4.15182055675e-11, 2.852e-07, 4.1388904563e-11, 2.854e-07, 4.12596771724e-11, 2.856e-07, 4.1130543597e-11, 2.858e-07, 4.10015265452e-11, 2.86e-07, 4.08726511625e-11, 2.862e-07, 4.0743944958e-11, 2.864e-07, 4.06154377279e-11, 2.866e-07, 4.04871614759e-11, 2.868e-07, 4.03591503319e-11, 2.87e-07, 4.02314404673e-11, 2.872e-07, 4.01040700094e-11, 2.874e-07, 3.99770789538e-11, 2.876e-07, 3.98505090753e-11, 2.878e-07, 3.97244038381e-11, 2.88e-07, 3.95988083047e-11, 2.882e-07, 3.94737690456e-11, 2.884e-07, 3.93493340471e-11, 2.886e-07, 3.9225552621e-11, 2.888e-07, 3.91024753134e-11, 2.89e-07, 3.8980153815e-11, 2.892e-07, 3.88586408722e-11, 2.894e-07, 3.87379901992e-11, 2.896e-07, 3.86182563916e-11, 2.898e-07, 3.84994948423e-11, 2.9e-07, 3.83817616584e-11, 2.902e-07, 3.8265113581e-11, 2.904e-07, 3.81496079067e-11, 2.906e-07, 3.80353024122e-11, 2.908e-07, 3.7922255281e-11, 2.91e-07, 3.78105250335e-11, 2.912e-07, 3.77001704593e-11, 2.914e-07, 3.75912505533e-11, 2.916e-07, 3.74838244543e-11, 2.918e-07, 3.73779513873e-11, 2.92e-07, 3.72736906093e-11, 2.922e-07, 3.71711013573e-11, 2.924e-07, 3.70702428015e-11, 2.926e-07, 3.69711740003e-11, 2.928e-07, 3.68739538598e-11, 2.93e-07, 3.67786410962e-11, 2.932e-07, 3.6685294202e-11, 2.934e-07, 3.65939714157e-11, 2.936e-07, 3.65047306944e-11, 2.938e-07, 3.64176296902e-11, 2.94e-07, 3.63327257298e-11, 2.942e-07, 3.62500757975e-11, 2.944e-07, 3.61697365211e-11, 2.946e-07, 3.60917641612e-11, 2.948e-07, 3.60162146031e-11, 2.95e-07, 3.59431433527e-11, 2.952e-07, 3.58726055338e-11, 2.954e-07, 3.58046558891e-11, 2.956e-07, 3.57393487839e-11, 2.958e-07, 3.56767382121e-11, 2.96e-07, 3.56168778044e-11, 2.962e-07, 3.55598208394e-11, 2.964e-07, 3.55056202564e-11, 2.966e-07, 3.54543286711e-11, 2.968e-07, 3.54059983922e-11, 2.97e-07, 3.53606814409e-11, 2.972e-07, 3.53184295715e-11, 2.974e-07, 3.52792942942e-11, 2.976e-07, 3.52433268989e-11, 2.978e-07, 3.52105784809e-11, 2.98e-07, 3.51810999676e-11, 2.982e-07, 3.51549421468e-11, 2.984e-07, 3.51321556954e-11, 2.986e-07, 3.511279121e-11, 2.988e-07, 3.50968992376e-11, 2.99e-07, 3.50845303072e-11, 2.992e-07, 3.50757349626e-11, 2.994e-07, 3.50705637954e-11, 2.996e-07, 3.50690674777e-11, 2.998e-07, 3.50712967969e-11, 3e-07, 3.50773026887e-11, 3.002e-07, 3.50871362719e-11, 3.004e-07, 3.51008488821e-11, 3.006e-07, 3.51184921062e-11, 3.008e-07, 3.51401178157e-11, 3.01e-07, 3.51657782009e-11, 3.012e-07, 3.51955258037e-11, 3.014e-07, 3.52294135505e-11, 3.016e-07, 3.5267494784e-11, 3.018e-07, 3.53098232952e-11, 3.02e-07, 3.53564533531e-11, 3.022e-07, 3.54074397352e-11, 3.024e-07, 3.54628377553e-11, 3.026e-07, 3.55227032915e-11, 3.028e-07, 3.55870928117e-11, 3.03e-07, 3.56560633986e-11, 3.032e-07, 3.57296727726e-11, 3.034e-07, 3.58079793133e-11, 3.036e-07, 3.58910420786e-11, 3.038e-07, 3.59789208228e-11, 3.04e-07, 3.60716760111e-11, 3.042e-07, 3.61693688334e-11, 3.044e-07, 3.62720612139e-11, 3.046e-07, 3.63798158196e-11, 3.048e-07, 3.64926960643e-11, 3.05e-07, 3.66107661113e-11, 3.052e-07, 3.67340908708e-11, 3.054e-07, 3.68627359954e-11, 3.056e-07, 3.69967678709e-11, 3.058e-07, 3.71362536033e-11, 3.06e-07, 3.72812610014e-11, 3.062e-07, 3.7431858555e-11, 3.064e-07, 3.75881154079e-11, 3.066e-07, 3.7750101326e-11, 3.068e-07, 3.79178866597e-11, 3.07e-07, 3.80915423e-11, 3.072e-07, 3.82711396294e-11, 3.074e-07, 3.8456750465e-11, 3.076e-07, 3.86484469951e-11, 3.078e-07, 3.88463017087e-11, 3.08e-07, 3.90503873163e-11, 3.082e-07, 3.92607766628e-11, 3.084e-07, 3.94775426316e-11, 3.086e-07, 3.97007580393e-11, 3.088e-07, 3.99304955205e-11, 3.09e-07, 4.01668274023e-11, 3.092e-07, 4.04098255677e-11, 3.094e-07, 4.06595613076e-11, 3.096e-07, 4.09161051609e-11, 3.098e-07, 4.11795267417e-11, 3.1e-07, 4.14498945532e-11, 3.102e-07, 4.17272757876e-11, 3.104e-07, 4.20117361118e-11, 3.106e-07, 4.23033394374e-11, 3.108e-07, 4.26021476751e-11, 3.11e-07, 4.29082204727e-11, 3.112e-07, 4.32216149359e-11, 3.114e-07, 4.35423853311e-11, 3.116e-07, 4.38705827701e-11, 3.118e-07, 4.42062548755e-11, 3.12e-07, 4.45494454271e-11, 3.122e-07, 4.49001939876e-11, 3.124e-07, 4.52585355081e-11, 3.126e-07, 4.56244999126e-11, 3.128e-07, 4.59981116604e-11, 3.13e-07, 4.63793892883e-11, 3.132e-07, 4.67683449293e-11, 3.134e-07, 4.716498381e-11, 3.136e-07, 4.75693037266e-11, 3.138e-07, 4.79812944974e-11, 3.14e-07, 4.84009373955e-11, 3.142e-07, 4.88282045589e-11, 3.144e-07, 4.92630583806e-11, 3.146e-07, 4.97054508795e-11, 3.148e-07, 5.0155323051e-11, 3.15e-07, 5.06126042019e-11, 3.152e-07, 5.10772112683e-11, 3.154e-07, 5.15490481196e-11, 3.156e-07, 5.20280048505e-11, 3.158e-07, 5.25139570636e-11, 3.16e-07, 5.30067651449e-11, 3.162e-07, 5.35062735359e-11, 3.164e-07, 5.40123100052e-11, 3.166e-07, 5.45246849246e-11, 3.168e-07, 5.5043190552e-11, 3.17e-07, 5.55676003288e-11, 3.172e-07, 5.60976681939e-11, 3.174e-07, 5.6633127922e-11, 3.176e-07, 5.7173692492e-11, 3.178e-07, 5.77190534903e-11, 3.18e-07, 5.82688805586e-11, 3.182e-07, 5.8822820891e-11, 3.184e-07, 5.93804987897e-11, 3.186e-07, 5.99415152862e-11, 3.188e-07, 6.0505447837e-11, 3.19e-07, 6.1071850102e-11, 3.192e-07, 6.16402518139e-11, 3.194e-07, 6.22101587481e-11, 3.196e-07, 6.27810528015e-11, 3.198e-07, 6.33523921878e-11, 3.2e-07, 6.392361176e-11, 3.202e-07, 6.44941234659e-11, 3.204e-07, 6.50633169458e-11, 3.206e-07, 6.56305602781e-11, 3.208e-07, 6.61952008811e-11, 3.21e-07, 6.67565665743e-11, 3.212e-07, 6.73139668045e-11, 3.214e-07, 6.78666940412e-11, 3.216e-07, 6.84140253401e-11, 3.218e-07, 6.89552240786e-11, 3.22e-07, 6.94895418597e-11, 3.222e-07, 7.0016220582e-11, 3.224e-07, 7.05344946715e-11, 3.226e-07, 7.10435934677e-11, 3.228e-07, 7.15427437554e-11, 3.23e-07, 7.20311724319e-11, 3.232e-07, 7.25081092961e-11, 3.234e-07, 7.29727899445e-11, 3.236e-07, 7.34244587582e-11, 3.238e-07, 7.38623719603e-11, 3.24e-07, 7.42858007253e-11, 3.242e-07, 7.46940343166e-11, 3.244e-07, 7.50863832295e-11, 3.246e-07, 7.5462182315e-11, 3.248e-07, 7.58207938585e-11, 3.25e-07, 7.61616105878e-11, 3.252e-07, 7.64840585843e-11, 3.254e-07, 7.6787600071e-11, 3.256e-07, 7.70717360516e-11, 3.258e-07, 7.73360087765e-11, 3.26e-07, 7.75800040121e-11, 3.262e-07, 7.78033530912e-11, 3.264e-07, 7.80057347254e-11, 3.266e-07, 7.8186876561e-11, 3.268e-07, 7.83465564635e-11, 3.27e-07, 7.84846035193e-11, 3.272e-07, 7.86008987437e-11, 3.274e-07, 7.86953754901e-11, 3.276e-07, 7.87680195571e-11, 3.278e-07, 7.88188689933e-11, 3.28e-07, 7.88480136042e-11, 3.282e-07, 7.88555941665e-11, 3.284e-07, 7.88418013608e-11, 3.286e-07, 7.88068744337e-11, 3.288e-07, 7.87510996059e-11, 3.29e-07, 7.86748082429e-11, 3.292e-07, 7.85783748079e-11, 3.294e-07, 7.84622146187e-11, 3.296e-07, 7.83267814302e-11, 3.298e-07, 7.81725648681e-11, 3.3e-07, 7.80000877365e-11, 3.302e-07, 7.78099032251e-11, 3.304e-07, 7.76025920409e-11, 3.306e-07, 7.73787594888e-11, 3.308e-07, 7.71390325249e-11, 3.31e-07, 7.68840568059e-11, 3.312e-07, 7.66144937561e-11, 3.314e-07, 7.63310176734e-11, 3.316e-07, 7.60343128921e-11, 3.318e-07, 7.57250710217e-11, 3.32e-07, 7.54039882755e-11, 3.322e-07, 7.50717629045e-11, 3.324e-07, 7.47290927473e-11, 3.326e-07, 7.43766729068e-11, 3.328e-07, 7.40151935626e-11, 3.33e-07, 7.36453379231e-11, 3.332e-07, 7.32677803259e-11, 3.334e-07, 7.28831844851e-11, 3.336e-07, 7.24922018911e-11, 3.338e-07, 7.20954703602e-11, 3.34e-07, 7.16936127339e-11, 3.342e-07, 7.12872357252e-11, 3.344e-07, 7.08769289092e-11, 3.346e-07, 7.04632638519e-11, 3.348e-07, 7.00467933741e-11, 3.35e-07, 6.96280509434e-11, 3.352e-07, 6.92075501876e-11, 3.354e-07, 6.87857845246e-11, 3.356e-07, 6.83632268991e-11, 3.358e-07, 6.79403296215e-11, 3.36e-07, 6.75175242996e-11, 3.362e-07, 6.70952218573e-11, 3.364e-07, 6.66738126313e-11, 3.366e-07, 6.62536665405e-11, 3.368e-07, 6.58351333192e-11, 3.37e-07, 6.54185428088e-11, 3.372e-07, 6.50042053003e-11, 3.374e-07, 6.45924119219e-11, 3.376e-07, 6.41834350654e-11, 3.378e-07, 6.37775288466e-11, 3.38e-07, 6.33749295925e-11, 3.382e-07, 6.29758563528e-11, 3.384e-07, 6.2580511429e-11, 3.386e-07, 6.21890809183e-11, 3.388e-07, 6.18017352673e-11, 3.39e-07, 6.14186298326e-11, 3.392e-07, 6.10399054451e-11, 3.394e-07, 6.06656889748e-11, 3.396e-07, 6.02960938934e-11, 3.398e-07, 5.99312208326e-11, 3.4e-07, 5.95711581362e-11, 3.402e-07, 5.9215982404e-11, 3.404e-07, 5.88657590255e-11, 3.406e-07, 5.85205427033e-11, 3.408e-07, 5.81803779637e-11, 3.41e-07, 5.78452996546e-11, 3.412e-07, 5.75153334293e-11, 3.414e-07, 5.71904962162e-11, 3.416e-07, 5.68707966734e-11, 3.418e-07, 5.65562356282e-11, 3.42e-07, 5.62468065015e-11, 3.422e-07, 5.59424957167e-11, 3.424e-07, 5.56432830931e-11, 3.426e-07, 5.53491422242e-11, 3.428e-07, 5.50600408412e-11, 3.43e-07, 5.47759411613e-11, 3.432e-07, 5.44968002215e-11, 3.434e-07, 5.4222570199e-11, 3.436e-07, 5.39531987166e-11, 3.438e-07, 5.36886291366e-11, 3.44e-07, 5.34288008399e-11, 3.442e-07, 5.31736494942e-11, 3.444e-07, 5.29231073099e-11, 3.446e-07, 5.26771032846e-11, 3.448e-07, 5.24355634372e-11, 3.45e-07, 5.21984110309e-11, 3.452e-07, 5.19655667876e-11, 3.454e-07, 5.1736949092e-11, 3.456e-07, 5.15124741882e-11, 3.458e-07, 5.12920563666e-11, 3.46e-07, 5.1075608145e-11, 3.462e-07, 5.08630404404e-11, 3.464e-07, 5.06542627363e-11, 3.466e-07, 5.0449183242e-11, 3.468e-07, 5.02477090469e-11, 3.47e-07, 5.00497462694e-11, 3.472e-07, 4.9855200201e-11, 3.474e-07, 4.9663975445e-11, 3.476e-07, 4.94759760523e-11, 3.478e-07, 4.92911056521e-11, 3.48e-07, 4.91092675798e-11, 3.482e-07, 4.89303650018e-11, 3.484e-07, 4.87543010365e-11, 3.486e-07, 4.85809788733e-11, 3.488e-07, 4.84103018895e-11, 3.49e-07, 4.82421737636e-11, 3.492e-07, 4.80764985883e-11, 3.494e-07, 4.79131809798e-11, 3.496e-07, 4.77521261868e-11, 3.498e-07, 4.75932401972e-11, 3.5e-07, 4.74364298431e-11, 3.502e-07, 4.72816029046e-11, 3.504e-07, 4.71286682123e-11, 3.506e-07, 4.6977535748e-11, 3.508e-07, 4.68281167441e-11, 3.51e-07, 4.66803237819e-11, 3.512e-07, 4.65340708881e-11, 3.514e-07, 4.63892736298e-11, 3.516e-07, 4.6245849208e-11, 3.518e-07, 4.61037165496e-11, 3.52e-07, 4.59627963972e-11, 3.522e-07, 4.58230113974e-11, 3.524e-07, 4.5684286187e-11, 3.526e-07, 4.55465474767e-11, 3.528e-07, 4.54097241327e-11, 3.53e-07, 4.5273747256e-11, 3.532e-07, 4.51385502587e-11, 3.534e-07, 4.50040689373e-11, 3.536e-07, 4.48702415436e-11, 3.538e-07, 4.47370088517e-11, 3.54e-07, 4.46043142221e-11, 3.542e-07, 4.44721036614e-11, 3.544e-07, 4.43403258796e-11, 3.546e-07, 4.42089323418e-11, 3.548e-07, 4.40778773168e-11, 3.55e-07, 4.39471179213e-11, 3.552e-07, 4.3816614159e-11, 3.554e-07, 4.36863289559e-11, 3.556e-07, 4.35562281901e-11, 3.558e-07, 4.3426280717e-11, 3.56e-07, 4.32964583898e-11, 3.562e-07, 4.31667360743e-11, 3.564e-07, 4.30370916589e-11, 3.566e-07, 4.29075060593e-11, 3.568e-07, 4.27779632179e-11, 3.57e-07, 4.26484500978e-11, 3.572e-07, 4.25189566718e-11, 3.574e-07, 4.23894759055e-11, 3.576e-07, 4.22600037361e-11, 3.578e-07, 4.21305390449e-11, 3.58e-07, 4.20010836257e-11, 3.582e-07, 4.18716421475e-11, 3.584e-07, 4.17422221128e-11, 3.586e-07, 4.16128338108e-11, 3.588e-07, 4.14834902661e-11, 3.59e-07, 4.13542071835e-11, 3.592e-07, 4.12250028874e-11, 3.594e-07, 4.1095898259e-11, 3.596e-07, 4.09669166679e-11, 3.598e-07, 4.08380839014e-11, 3.6e-07, 4.07094280901e-11, 3.602e-07, 4.05809796308e-11, 3.604e-07, 4.0452771106e-11, 3.606e-07, 4.0324837202e-11, 3.608e-07, 4.01972146237e-11, 3.61e-07, 4.00699420087e-11, 3.612e-07, 3.99430598389e-11, 3.614e-07, 3.98166103514e-11, 3.616e-07, 3.96906374484e-11, 3.618e-07, 3.95651866063e-11, 3.62e-07, 3.94403047844e-11, 3.622e-07, 3.93160403339e-11, 3.624e-07, 3.91924429067e-11, 3.626e-07, 3.90695633651e-11, 3.628e-07, 3.89474536917e-11, 3.63e-07, 3.88261669014e-11, 3.632e-07, 3.87057569533e-11, 3.634e-07, 3.85862786653e-11, 3.636e-07, 3.846778763e-11, 3.638e-07, 3.83503401326e-11, 3.64e-07, 3.82339930708e-11, 3.642e-07, 3.81188038774e-11, 3.644e-07, 3.80048304454e-11, 3.646e-07, 3.78921310556e-11, 3.648e-07, 3.7780764307e-11, 3.65e-07, 3.76707890505e-11, 3.652e-07, 3.75622643255e-11, 3.654e-07, 3.74552492995e-11, 3.656e-07, 3.73498032115e-11, 3.658e-07, 3.72459853177e-11, 3.66e-07, 3.71438548419e-11, 3.662e-07, 3.70434709284e-11, 3.664e-07, 3.69448925986e-11, 3.666e-07, 3.68481787112e-11, 3.668e-07, 3.67533879256e-11, 3.67e-07, 3.66605786689e-11, 3.672e-07, 3.65698091065e-11, 3.674e-07, 3.64811371159e-11, 3.676e-07, 3.63946202636e-11, 3.678e-07, 3.63103157862e-11, 3.68e-07, 3.62282805733e-11, 3.682e-07, 3.61485711551e-11, 3.684e-07, 3.60712436922e-11, 3.686e-07, 3.59963539683e-11, 3.688e-07, 3.59239573869e-11, 3.69e-07, 3.58541089692e-11, 3.692e-07, 3.57868633562e-11, 3.694e-07, 3.57222748129e-11, 3.696e-07, 3.56603972346e-11, 3.698e-07, 3.56012841564e-11, 3.7e-07, 3.55449887644e-11, 3.702e-07, 3.54915639097e-11, 3.704e-07, 3.54410621235e-11, 3.706e-07, 3.53935356355e-11, 3.708e-07, 3.53490363931e-11, 3.71e-07, 3.53076160829e-11, 3.712e-07, 3.52693261534e-11, 3.714e-07, 3.52342178398e-11, 3.716e-07, 3.52023421896e-11, 3.718e-07, 3.517375009e-11, 3.72e-07, 3.5148492296e-11, 3.722e-07, 3.512661946e-11, 3.724e-07, 3.51081821623e-11, 3.726e-07, 3.50932309417e-11, 3.728e-07, 3.50818163283e-11, 3.73e-07, 3.50739888752e-11, 3.732e-07, 3.50697991924e-11, 3.734e-07, 3.50692979796e-11, 3.736e-07, 3.50725360607e-11, 3.738e-07, 3.50795644171e-11, 3.74e-07, 3.50904342226e-11, 3.742e-07, 3.51051968769e-11, 3.744e-07, 3.51239040399e-11, 3.746e-07, 3.51466076654e-11, 3.748e-07, 3.51733600349e-11, 3.75e-07, 3.52042137903e-11, 3.752e-07, 3.52392219666e-11, 3.754e-07, 3.52784380238e-11, 3.756e-07, 3.53219158782e-11, 3.758e-07, 3.53697099326e-11, 3.76e-07, 3.54218751055e-11, 3.762e-07, 3.54784668597e-11, 3.764e-07, 3.55395412291e-11, 3.766e-07, 3.56051548441e-11, 3.768e-07, 3.56753649567e-11, 3.77e-07, 3.57502294619e-11, 3.772e-07, 3.58298069198e-11, 3.774e-07, 3.59141565736e-11, 3.776e-07, 3.60033383668e-11, 3.778e-07, 3.60974129582e-11, 3.78e-07, 3.61964417338e-11, 3.782e-07, 3.63004868166e-11, 3.784e-07, 3.64096110735e-11, 3.786e-07, 3.65238781199e-11, 3.788e-07, 3.66433523194e-11, 3.79e-07, 3.67680987825e-11, 3.792e-07, 3.68981833596e-11, 3.794e-07, 3.70336726311e-11, 3.796e-07, 3.71746338938e-11, 3.798e-07, 3.73211351414e-11, 3.8e-07, 3.74732450424e-11, 3.802e-07, 3.76310329107e-11, 3.804e-07, 3.77945686732e-11, 3.806e-07, 3.79639228298e-11, 3.808e-07, 3.81391664087e-11, 3.81e-07, 3.83203709148e-11, 3.812e-07, 3.85076082715e-11, 3.814e-07, 3.8700950755e-11, 3.816e-07, 3.89004709219e-11, 3.818e-07, 3.91062415276e-11, 3.82e-07, 3.93183354372e-11, 3.822e-07, 3.95368255269e-11, 3.824e-07, 3.97617845762e-11, 3.826e-07, 3.99932851499e-11, 3.828e-07, 4.02313994698e-11, 3.83e-07, 4.04761992748e-11, 3.832e-07, 4.07277556704e-11, 3.834e-07, 4.09861389647e-11, 3.836e-07, 4.12514184923e-11, 3.838e-07, 4.15236624249e-11, 3.84e-07, 4.18029375668e-11, 3.842e-07, 4.20893091369e-11, 3.844e-07, 4.23828405345e-11, 3.846e-07, 4.26835930895e-11, 3.848e-07, 4.29916257952e-11, 3.85e-07, 4.33069950251e-11, 3.852e-07, 4.36297542306e-11, 3.854e-07, 4.39599536204e-11, 3.856e-07, 4.42976398212e-11, 3.858e-07, 4.46428555185e-11, 3.86e-07, 4.49956390764e-11, 3.862e-07, 4.53560241385e-11, 3.864e-07, 4.57240392054e-11, 3.866e-07, 4.60997071928e-11, 3.868e-07, 4.64830449664e-11, 3.87e-07, 4.68740628557e-11, 3.872e-07, 4.7272764145e-11, 3.874e-07, 4.76791445435e-11, 3.876e-07, 4.80931916325e-11, 3.878e-07, 4.85148842914e-11, 3.88e-07, 4.89441921032e-11, 3.882e-07, 4.93810747388e-11, 3.884e-07, 4.98254813221e-11, 3.886e-07, 5.02773497772e-11, 3.888e-07, 5.07366061577e-11, 3.89e-07, 5.12031639608e-11, 3.892e-07, 5.16769234284e-11, 3.894e-07, 5.21577708358e-11, 3.896e-07, 5.26455777721e-11, 3.898e-07, 5.31402004149e-11, 3.9e-07, 5.36414788014e-11, 3.902e-07, 5.41492361012e-11, 3.904e-07, 5.46632778936e-11, 3.906e-07, 5.51833914538e-11, 3.908e-07, 5.57093450544e-11, 3.91e-07, 5.62408872855e-11, 3.912e-07, 5.67777464e-11, 3.914e-07, 5.73196296912e-11, 3.916e-07, 5.7866222907e-11, 3.918e-07, 5.84171897104e-11, 3.92e-07, 5.89721711917e-11, 3.922e-07, 5.95307854405e-11, 3.924e-07, 6.00926271865e-11, 3.926e-07, 6.06572675165e-11, 3.928e-07, 6.12242536762e-11, 3.93e-07, 6.1793108966e-11, 3.932e-07, 6.2363332739e-11, 3.934e-07, 6.29344005102e-11, 3.936e-07, 6.35057641856e-11, 3.938e-07, 6.4076852419e-11, 3.94e-07, 6.46470711054e-11, 3.942e-07, 6.52158040174e-11, 3.944e-07, 6.57824135925e-11, 3.946e-07, 6.63462418769e-11, 3.948e-07, 6.69066116309e-11, 3.95e-07, 6.74628276e-11, 3.952e-07, 6.80141779554e-11, 3.954e-07, 6.85599359035e-11, 3.956e-07, 6.90993614673e-11, 3.958e-07, 6.96317034345e-11, 3.96e-07, 7.01562014724e-11, 3.962e-07, 7.06720884008e-11, 3.964e-07, 7.1178592619e-11, 3.966e-07, 7.1674940675e-11, 3.968e-07, 7.21603599664e-11, 3.97e-07, 7.26340815597e-11, 3.972e-07, 7.30953431132e-11, 3.974e-07, 7.35433918839e-11, 3.976e-07, 7.39774878016e-11, 3.978e-07, 7.43969065878e-11, 3.98e-07, 7.4800942897e-11, 3.982e-07, 7.51889134573e-11, 3.984e-07, 7.5560160184e-11, 3.986e-07, 7.59140532427e-11, 3.988e-07, 7.62499940334e-11, 3.99e-07, 7.65674180711e-11, 3.992e-07, 7.68657977366e-11, 3.994e-07, 7.71446448714e-11, 3.996e-07, 7.7403513193e-11, 3.998e-07, 7.76420005076e-11, 4e-07, 7.78597506989e-11, 4.002e-07, 7.80564554724e-11, 4.004e-07, 7.82318558404e-11, 4.006e-07, 7.8385743332e-11, 4.008e-07, 7.85179609156e-11, 4.01e-07, 7.86284036286e-11, 4.012e-07, 7.87170189045e-11, 4.014e-07, 7.87838065994e-11, 4.016e-07, 7.8828818716e-11, 4.018e-07, 7.88521588316e-11, 4.02e-07, 7.8853981235e-11, 4.022e-07, 7.88344897858e-11, 4.024e-07, 7.87939365068e-11, 4.026e-07, 7.87326199263e-11, 4.028e-07, 7.86508831883e-11, 4.03e-07, 7.85491119507e-11, 4.032e-07, 7.84277320932e-11, 4.034e-07, 7.82872072575e-11, 4.036e-07, 7.81280362445e-11, 4.038e-07, 7.79507502928e-11, 4.04e-07, 7.77559102628e-11, 4.042e-07, 7.75441037528e-11, 4.044e-07, 7.73159421696e-11, 4.046e-07, 7.70720577785e-11, 4.048e-07, 7.68131007556e-11, 4.05e-07, 7.6539736263e-11, 4.052e-07, 7.62526415684e-11, 4.054e-07, 7.59525032269e-11, 4.056e-07, 7.56400143419e-11, 4.058e-07, 7.53158719211e-11, 4.06e-07, 7.49807743401e-11, 4.062e-07, 7.46354189258e-11, 4.064e-07, 7.42804996688e-11, 4.066e-07, 7.39167050722e-11, 4.068e-07, 7.35447161436e-11, 4.07e-07, 7.31652045347e-11, 4.072e-07, 7.27788308293e-11, 4.074e-07, 7.23862429833e-11, 4.076e-07, 7.19880749146e-11, 4.078e-07, 7.15849452426e-11, 4.08e-07, 7.11774561731e-11, 4.082e-07, 7.07661925267e-11, 4.084e-07, 7.03517209044e-11, 4.086e-07, 6.99345889865e-11, 4.088e-07, 6.95153249576e-11, 4.09e-07, 6.90944370523e-11, 4.092e-07, 6.8672413214e-11, 4.094e-07, 6.82497208605e-11, 4.096e-07, 6.78268067476e-11, 4.098e-07, 6.74040969258e-11, 4.1e-07, 6.69819967798e-11, 4.102e-07, 6.65608911461e-11, 4.104e-07, 6.61411444999e-11, 4.106e-07, 6.57231012046e-11, 4.108e-07, 6.5307085818e-11, 4.11e-07, 6.48934034472e-11, 4.112e-07, 6.44823401476e-11, 4.114e-07, 6.40741633587e-11, 4.116e-07, 6.3669122372e-11, 4.118e-07, 6.32674488258e-11, 4.12e-07, 6.28693572212e-11, 4.122e-07, 6.24750454562e-11, 4.124e-07, 6.20846953718e-11, 4.126e-07, 6.16984733088e-11, 4.128e-07, 6.13165306691e-11, 4.13e-07, 6.09390044805e-11, 4.132e-07, 6.05660179614e-11, 4.134e-07, 6.01976810821e-11, 4.136e-07, 5.98340911219e-11, 4.138e-07, 5.94753332191e-11, 4.14e-07, 5.91214809122e-11, 4.142e-07, 5.87725966711e-11, 4.144e-07, 5.84287324171e-11, 4.146e-07, 5.80899300301e-11, 4.148e-07, 5.77562218429e-11, 4.15e-07, 5.74276311214e-11, 4.152e-07, 5.71041725296e-11, 4.154e-07, 5.67858525813e-11, 4.156e-07, 5.64726700744e-11, 4.158e-07, 5.61646165121e-11, 4.16e-07, 5.58616765069e-11, 4.162e-07, 5.55638281704e-11, 4.164e-07, 5.52710434874e-11, 4.166e-07, 5.49832886753e-11, 4.168e-07, 5.47005245285e-11, 4.17e-07, 5.44227067487e-11, 4.172e-07, 5.4149786261e-11, 4.174e-07, 5.38817095163e-11, 4.176e-07, 5.36184187812e-11, 4.178e-07, 5.33598524139e-11, 4.18e-07, 5.31059451296e-11, 4.182e-07, 5.28566282527e-11, 4.184e-07, 5.26118299585e-11, 4.186e-07, 5.23714755048e-11, 4.188e-07, 5.21354874519e-11, 4.19e-07, 5.19037858746e-11, 4.192e-07, 5.16762885643e-11, 4.194e-07, 5.14529112222e-11, 4.196e-07, 5.12335676458e-11, 4.198e-07, 5.10181699063e-11, 4.2e-07, 5.080662852e-11, 4.202e-07, 5.05988526127e-11, 4.204e-07, 5.03947500783e-11, 4.206e-07, 5.01942277312e-11, 4.208e-07, 4.99971914538e-11, 4.21e-07, 4.98035463394e-11, 4.212e-07, 4.96131968299e-11, 4.214e-07, 4.94260468502e-11, 4.216e-07, 4.92419999384e-11, 4.218e-07, 4.90609593724e-11, 4.22e-07, 4.88828282937e-11, 4.222e-07, 4.87075098284e-11, 4.224e-07, 4.8534907205e-11, 4.226e-07, 4.83649238704e-11, 4.228e-07, 4.81974636035e-11, 4.23e-07, 4.80324306266e-11, 4.232e-07, 4.78697297154e-11, 4.234e-07, 4.77092663063e-11, 4.236e-07, 4.75509466038e-11, 4.238e-07, 4.73946776842e-11, 4.24e-07, 4.72403675996e-11, 4.242e-07, 4.70879254799e-11, 4.244e-07, 4.69372616328e-11, 4.246e-07, 4.67882876433e-11, 4.248e-07, 4.66409164712e-11, 4.25e-07, 4.64950625475e-11, 4.252e-07, 4.63506418687e-11, 4.254e-07, 4.62075720901e-11, 4.256e-07, 4.60657726174e-11, 4.258e-07, 4.59251646956e-11, 4.26e-07, 4.57856714973e-11, 4.262e-07, 4.56472182078e-11, 4.264e-07, 4.55097321085e-11, 4.266e-07, 4.53731426579e-11, 4.268e-07, 4.52373815698e-11, 4.27e-07, 4.51023828895e-11, 4.272e-07, 4.49680830657e-11, 4.274e-07, 4.48344210208e-11, 4.276e-07, 4.47013382171e-11, 4.278e-07, 4.45687787196e-11, 4.28e-07, 4.44366892553e-11, 4.282e-07, 4.43050192686e-11, 4.284e-07, 4.41737209729e-11, 4.286e-07, 4.40427493972e-11, 4.288e-07, 4.39120624294e-11, 4.29e-07, 4.37816208547e-11, 4.292e-07, 4.36513883885e-11, 4.294e-07, 4.35213317059e-11, 4.296e-07, 4.33914204655e-11, 4.298e-07, 4.32616273276e-11, 4.3e-07, 4.31319279688e-11, 4.302e-07, 4.30023010899e-11, 4.304e-07, 4.28727284193e-11, 4.306e-07, 4.27431947111e-11, 4.308e-07, 4.26136877376e-11, 4.31e-07, 4.24841982768e-11, 4.312e-07, 4.23547200944e-11, 4.314e-07, 4.22252499207e-11, 4.316e-07, 4.20957874222e-11, 4.318e-07, 4.19663351684e-11, 4.32e-07, 4.18368985932e-11, 4.322e-07, 4.17074859519e-11, 4.324e-07, 4.15781082733e-11, 4.326e-07, 4.14487793069e-11, 4.328e-07, 4.13195154669e-11, 4.33e-07, 4.11903357704e-11, 4.332e-07, 4.10612617734e-11, 4.334e-07, 4.09323175015e-11, 4.336e-07, 4.08035293787e-11, 4.338e-07, 4.06749261514e-11, 4.34e-07, 4.05465388112e-11, 4.342e-07, 4.04184005136e-11, 4.344e-07, 4.02905464949e-11, 4.346e-07, 4.01630139877e-11, 4.348e-07, 4.0035842133e-11, 4.35e-07, 3.9909071893e-11, 4.352e-07, 3.97827459605e-11, 4.354e-07, 3.96569086692e-11, 4.356e-07, 3.95316059026e-11, 4.358e-07, 3.94068850026e-11, 4.36e-07, 3.92827946784e-11, 4.362e-07, 3.91593849157e-11, 4.364e-07, 3.90367068863e-11, 4.366e-07, 3.89148128587e-11, 4.368e-07, 3.87937561094e-11, 4.37e-07, 3.86735908368e-11, 4.372e-07, 3.85543720748e-11, 4.374e-07, 3.84361556098e-11, 4.376e-07, 3.83189978992e-11, 4.378e-07, 3.82029559919e-11, 4.38e-07, 3.80880874515e-11, 4.382e-07, 3.79744502821e-11, 4.384e-07, 3.78621028565e-11, 4.386e-07, 3.77511038478e-11, 4.388e-07, 3.76415121636e-11, 4.39e-07, 3.75333868835e-11, 4.392e-07, 3.74267871996e-11, 4.394e-07, 3.73217723605e-11, 4.396e-07, 3.72184016188e-11, 4.398e-07, 3.71167341813e-11, 4.4e-07, 3.70168291633e-11, 4.402e-07, 3.69187455464e-11, 4.404e-07, 3.68225421392e-11, 4.406e-07, 3.67282775419e-11, 4.408e-07, 3.6636010114e-11, 4.41e-07, 3.65457979462e-11, 4.412e-07, 3.64576988345e-11, 4.414e-07, 3.63717702587e-11, 4.416e-07, 3.62880693636e-11, 4.418e-07, 3.62066529437e-11, 4.42e-07, 3.61275774306e-11, 4.422e-07, 3.60508988844e-11, 4.424e-07, 3.5976672987e-11, 4.426e-07, 3.59049550392e-11, 4.428e-07, 3.58357999601e-11, 4.43e-07, 3.57692622891e-11, 4.432e-07, 3.57053961911e-11, 4.434e-07, 3.56442554639e-11, 4.436e-07, 3.55858935476e-11, 4.438e-07, 3.5530363537e-11, 4.44e-07, 3.54777181956e-11, 4.442e-07, 3.5428009972e-11, 4.444e-07, 3.5381291018e-11, 4.446e-07, 3.53376132089e-11, 4.448e-07, 3.5297028165e-11, 4.45e-07, 3.52595872751e-11, 4.452e-07, 3.52253417214e-11, 4.454e-07, 3.51943425058e-11, 4.456e-07, 3.51666404769e-11, 4.458e-07, 3.51422863595e-11, 4.46e-07, 3.51213307836e-11, 4.462e-07, 3.5103824315e-11, 4.464e-07, 3.50898174873e-11, 4.466e-07, 3.50793608334e-11, 4.468e-07, 3.50725049184e-11, 4.47e-07, 3.50693003731e-11, 4.472e-07, 3.50697979274e-11, 4.474e-07, 3.50740484438e-11, 4.476e-07, 3.50821029522e-11, 4.478e-07, 3.50940126836e-11, 4.48e-07, 3.51098291043e-11, 4.482e-07, 3.51296039497e-11, 4.484e-07, 3.51533892584e-11, 4.486e-07, 3.51812374052e-11, 4.488e-07, 3.52132011346e-11, 4.49e-07, 3.52493335924e-11, 4.492e-07, 3.52896883583e-11, 4.494e-07, 3.5334319476e-11, 4.496e-07, 3.5383281484e-11, 4.498e-07, 3.54366294441e-11, 4.5e-07, 3.549441897e-11, 4.502e-07, 3.5556706253e-11, 4.504e-07, 3.56235480883e-11, 4.506e-07, 3.56950018982e-11, 4.508e-07, 3.57711257543e-11, 4.51e-07, 3.58519783983e-11, 4.512e-07, 3.59376192598e-11, 4.514e-07, 3.6028108473e-11, 4.516e-07, 3.61235068908e-11, 4.518e-07, 3.62238760961e-11, 4.52e-07, 3.63292784111e-11, 4.522e-07, 3.64397769035e-11, 4.524e-07, 3.65554353893e-11, 4.526e-07, 3.66763184332e-11, 4.528e-07, 3.68024913451e-11, 4.53e-07, 3.69340201723e-11, 4.532e-07, 3.70709716893e-11, 4.534e-07, 3.72134133819e-11, 4.536e-07, 3.73614134274e-11, 4.538e-07, 3.75150406705e-11, 4.54e-07, 3.76743645932e-11, 4.542e-07, 3.78394552804e-11, 4.544e-07, 3.80103833784e-11, 4.546e-07, 3.81872200488e-11, 4.548e-07, 3.83700369146e-11, 4.55e-07, 3.85589060009e-11, 4.552e-07, 3.87538996666e-11, 4.554e-07, 3.89550905298e-11, 4.556e-07, 3.91625513847e-11, 4.558e-07, 3.93763551093e-11, 4.56e-07, 3.9596574565e-11, 4.562e-07, 3.98232824855e-11, 4.564e-07, 4.00565513566e-11, 4.566e-07, 4.02964532847e-11, 4.568e-07, 4.05430598541e-11, 4.57e-07, 4.07964419726e-11, 4.572e-07, 4.10566697051e-11, 4.574e-07, 4.1323812093e-11, 4.576e-07, 4.15979369616e-11, 4.578e-07, 4.18791107119e-11, 4.58e-07, 4.21673980978e-11, 4.582e-07, 4.24628619883e-11, 4.584e-07, 4.2765563113e-11, 4.586e-07, 4.30755597906e-11, 4.588e-07, 4.33929076407e-11, 4.59e-07, 4.37176592762e-11, 4.592e-07, 4.40498639788e-11, 4.594e-07, 4.4389567353e-11, 4.596e-07, 4.47368109625e-11, 4.598e-07, 4.50916319446e-11, 4.6e-07, 4.54540626043e-11, 4.602e-07, 4.58241299876e-11, 4.604e-07, 4.62018554326e-11, 4.606e-07, 4.65872540991e-11, 4.608e-07, 4.69803344762e-11, 4.61e-07, 4.7381097868e-11, 4.612e-07, 4.77895378568e-11, 4.614e-07, 4.82056397453e-11, 4.616e-07, 4.86293799768e-11, 4.618e-07, 4.90607255345e-11, 4.62e-07, 4.94996333214e-11, 4.622e-07, 4.99460495199e-11, 4.624e-07, 5.0399908934e-11, 4.626e-07, 5.08611343146e-11, 4.628e-07, 5.13296356701e-11, 4.63e-07, 5.18053095632e-11, 4.632e-07, 5.2288038398e-11, 4.634e-07, 5.2777689698e-11, 4.636e-07, 5.32741153797e-11, 4.638e-07, 5.37771510238e-11, 4.64e-07, 5.42866151485e-11, 4.642e-07, 5.48023084891e-11, 4.644e-07, 5.5324013288e-11, 4.646e-07, 5.58514926e-11, 4.648e-07, 5.6384489619e-11, 4.65e-07, 5.69227270312e-11, 4.652e-07, 5.74659064021e-11, 4.654e-07, 5.80137076023e-11, 4.656e-07, 5.85657882809e-11, 4.658e-07, 5.91217833933e-11, 4.66e-07, 5.96813047906e-11, 4.662e-07, 6.02439408805e-11, 4.664e-07, 6.08092563656e-11, 4.666e-07, 6.137679207e-11, 4.668e-07, 6.19460648614e-11, 4.67e-07, 6.25165676785e-11, 4.672e-07, 6.30877696709e-11, 4.674e-07, 6.36591164625e-11, 4.676e-07, 6.42300305434e-11, 4.678e-07, 6.47999118016e-11, 4.68e-07, 6.53681381989e-11, 4.682e-07, 6.59340665997e-11, 4.684e-07, 6.64970337577e-11, 4.686e-07, 6.70563574658e-11, 4.688e-07, 6.76113378717e-11, 4.69e-07, 6.81612589643e-11, 4.692e-07, 6.87053902294e-11, 4.694e-07, 6.92429884757e-11, 4.696e-07, 6.97732998282e-11, 4.698e-07, 7.02955618864e-11, 4.7e-07, 7.08090060393e-11, 4.702e-07, 7.1312859931e-11, 4.704e-07, 7.18063500673e-11, 4.706e-07, 7.22887045491e-11, 4.708e-07, 7.27591559219e-11, 4.71e-07, 7.3216944122e-11, 4.712e-07, 7.36613195042e-11, 4.714e-07, 7.40915459298e-11, 4.716e-07, 7.45069038937e-11, 4.718e-07, 7.49066936682e-11, 4.72e-07, 7.52902384383e-11, 4.722e-07, 7.56568874048e-11, 4.724e-07, 7.60060188287e-11, 4.726e-07, 7.63370429896e-11, 4.728e-07, 7.66494050348e-11, 4.73e-07, 7.69425876898e-11, 4.732e-07, 7.72161138081e-11, 4.734e-07, 7.74695487339e-11, 4.736e-07, 7.77025024568e-11, 4.738e-07, 7.79146315368e-11, 4.74e-07, 7.81056407806e-11, 4.742e-07, 7.8275284654e-11, 4.744e-07, 7.84233684156e-11, 4.746e-07, 7.85497489618e-11, 4.748e-07, 7.86543353754e-11, 4.75e-07, 7.8737089172e-11, 4.752e-07, 7.87980242452e-11, 4.754e-07, 7.88372065107e-11, 4.756e-07, 7.88547532551e-11, 4.758e-07, 7.88508321971e-11, 4.76e-07, 7.8825660274e-11, 4.762e-07, 7.87795021652e-11, 4.764e-07, 7.871266857e-11, 4.766e-07, 7.86255142595e-11, 4.768e-07, 7.85184359212e-11, 4.77e-07, 7.83918698191e-11, 4.772e-07, 7.82462892941e-11, 4.774e-07, 7.80822021261e-11, 4.776e-07, 7.79001477849e-11, 4.778e-07, 7.77006945939e-11, 4.78e-07, 7.74844368315e-11, 4.782e-07, 7.72519917935e-11, 4.784e-07, 7.70039968419e-11, 4.786e-07, 7.67411064615e-11, 4.788e-07, 7.64639893445e-11, 4.79e-07, 7.61733255253e-11, 4.792e-07, 7.58698035822e-11, 4.794e-07, 7.55541179218e-11, 4.796e-07, 7.52269661634e-11, 4.798e-07, 7.48890466333e-11, 4.8e-07, 7.45410559818e-11, 4.802e-07, 7.41836869317e-11, 4.804e-07, 7.38176261652e-11, 4.806e-07, 7.34435523552e-11, 4.808e-07, 7.30621343438e-11, 4.81e-07, 7.26740294721e-11, 4.812e-07, 7.227988206e-11, 4.814e-07, 7.18803220363e-11, 4.816e-07, 7.14759637179e-11, 4.818e-07, 7.10674047334e-11, 4.82e-07, 7.06552250888e-11, 4.822e-07, 7.02399863696e-11, 4.824e-07, 6.98222310741e-11, 4.826e-07, 6.94024820714e-11, 4.828e-07, 6.89812421781e-11, 4.83e-07, 6.85589938466e-11, 4.832e-07, 6.81361989577e-11, 4.834e-07, 6.77132987098e-11, 4.836e-07, 6.72907135986e-11, 4.838e-07, 6.68688434786e-11, 4.84e-07, 6.64480676992e-11, 4.842e-07, 6.60287453101e-11, 4.844e-07, 6.56112153259e-11, 4.846e-07, 6.51957970463e-11, 4.848e-07, 6.47827904234e-11, 4.85e-07, 6.43724764713e-11, 4.852e-07, 6.39651177106e-11, 4.854e-07, 6.35609586447e-11, 4.856e-07, 6.31602262599e-11, 4.858e-07, 6.27631305476e-11, 4.86e-07, 6.23698650413e-11, 4.862e-07, 6.19806073663e-11, 4.864e-07, 6.15955197979e-11, 4.866e-07, 6.1214749824e-11, 4.868e-07, 6.08384307102e-11, 4.87e-07, 6.04666820634e-11, 4.872e-07, 6.00996103928e-11, 4.874e-07, 5.97373096652e-11, 4.876e-07, 5.9379861852e-11, 4.878e-07, 5.9027337469e-11, 4.88e-07, 5.86797961039e-11, 4.882e-07, 5.83372869331e-11, 4.884e-07, 5.79998492259e-11, 4.886e-07, 5.76675128346e-11, 4.888e-07, 5.73402986708e-11, 4.89e-07, 5.70182191674e-11, 4.892e-07, 5.67012787246e-11, 4.894e-07, 5.63894741416e-11, 4.896e-07, 5.60827950327e-11, 4.898e-07, 5.57812242278e-11, 4.9e-07, 5.54847381577e-11, 4.902e-07, 5.51933072243e-11, 4.904e-07, 5.49068961561e-11, 4.906e-07, 5.46254643486e-11, 4.908e-07, 5.43489661908e-11, 4.91e-07, 5.40773513777e-11, 4.912e-07, 5.3810565209e-11, 4.914e-07, 5.35485488754e-11, 4.916e-07, 5.32912397319e-11, 4.918e-07, 5.30385715591e-11, 4.92e-07, 5.27904748126e-11, 4.922e-07, 5.25468768626e-11, 4.924e-07, 5.23077022212e-11, 4.926e-07, 5.20728727613e-11, 4.928e-07, 5.18423079252e-11, 4.93e-07, 5.16159249246e-11, 4.932e-07, 5.13936389318e-11, 4.934e-07, 5.11753632635e-11, 4.936e-07, 5.09610095572e-11, 4.938e-07, 5.07504879401e-11, 4.94e-07, 5.05437071918e-11, 4.942e-07, 5.03405749017e-11, 4.944e-07, 5.01409976198e-11, 4.946e-07, 4.99448810029e-11, 4.948e-07, 4.9752129956e-11, 4.95e-07, 4.95626487693e-11, 4.952e-07, 4.93763412511e-11, 4.954e-07, 4.91931108574e-11, 4.956e-07, 4.90128608174e-11, 4.958e-07, 4.88354942569e-11, 4.96e-07, 4.86609143178e-11, 4.962e-07, 4.8489024276e-11, 4.964e-07, 4.83197276565e-11, 4.966e-07, 4.81529283464e-11, 4.968e-07, 4.79885307057e-11, 4.97e-07, 4.7826439677e-11, 4.972e-07, 4.76665608926e-11, 4.974e-07, 4.75088007807e-11, 4.976e-07, 4.73530666694e-11, 4.978e-07, 4.71992668903e-11, 4.98e-07, 4.70473108796e-11, 4.982e-07, 4.68971092781e-11, 4.984e-07, 4.67485740305e-11, 4.986e-07, 4.6601618482e-11, 4.988e-07, 4.64561574746e-11, 4.99e-07, 4.63121074412e-11, 4.992e-07, 4.61693864979e-11, 4.994e-07, 4.60279145354e-11, 4.996e-07, 4.58876133078e-11, 4.998e-07, 4.57484065196e-11, 5e-07, 4.56102199105e-11, 5.002e-07, 4.54729813386e-11, 5.004e-07, 4.53366208603e-11, 5.006e-07, 4.5201070808e-11, 5.008e-07, 4.50662658648e-11, 5.01e-07, 4.49321431371e-11, 5.012e-07, 4.47986422226e-11, 5.014e-07, 4.46657052761e-11, 5.016e-07, 4.45332770717e-11, 5.018e-07, 4.44013050605e-11, 5.02e-07, 4.42697394254e-11, 5.022e-07, 4.41385331309e-11, 5.024e-07, 4.40076419697e-11, 5.026e-07, 4.38770246038e-11, 5.028e-07, 4.37466426018e-11, 5.03e-07, 4.3616460471e-11, 5.032e-07, 4.34864456853e-11, 5.034e-07, 4.33565687074e-11, 5.036e-07, 4.32268030061e-11, 5.038e-07, 4.30971250692e-11, 5.04e-07, 4.29675144102e-11, 5.042e-07, 4.283795357e-11, 5.044e-07, 4.2708428114e-11, 5.046e-07, 4.25789266226e-11, 5.048e-07, 4.2449440678e-11, 5.05e-07, 4.2319964844e-11, 5.052e-07, 4.21904966422e-11, 5.054e-07, 4.20610365218e-11, 5.056e-07, 4.19315878252e-11, 5.058e-07, 4.18021567481e-11, 5.06e-07, 4.16727522953e-11, 5.062e-07, 4.1543386231e-11, 5.064e-07, 4.14140730261e-11, 5.066e-07, 4.12848297994e-11, 5.068e-07, 4.11556762562e-11, 5.07e-07, 4.10266346222e-11, 5.072e-07, 4.08977295741e-11, 5.074e-07, 4.07689881667e-11, 5.076e-07, 4.06404397571e-11, 5.078e-07, 4.05121159256e-11, 5.08e-07, 4.03840503946e-11, 5.082e-07, 4.02562789448e-11, 5.084e-07, 4.01288393294e-11, 5.086e-07, 4.00017711873e-11, 5.088e-07, 3.98751159539e-11, 5.09e-07, 3.97489167716e-11, 5.092e-07, 3.96232183988e-11, 5.094e-07, 3.94980671196e-11, 5.096e-07, 3.93735106519e-11, 5.098e-07, 3.92495980564e-11, 5.1e-07, 3.9126379646e-11, 5.102e-07, 3.90039068957e-11, 5.104e-07, 3.88822323532e-11, 5.106e-07, 3.8761409551e-11, 5.108e-07, 3.864149292e-11, 5.11e-07, 3.85225377042e-11, 5.112e-07, 3.84045998782e-11, 5.114e-07, 3.82877360657e-11, 5.116e-07, 3.81720034613e-11, 5.118e-07, 3.8057459754e-11, 5.12e-07, 3.79441630537e-11, 5.122e-07, 3.78321718205e-11, 5.124e-07, 3.77215447969e-11, 5.126e-07, 3.76123409425e-11, 5.128e-07, 3.75046193729e-11, 5.13e-07, 3.73984393006e-11, 5.132e-07, 3.72938599805e-11, 5.134e-07, 3.71909406575e-11, 5.136e-07, 3.70897405182e-11, 5.138e-07, 3.6990318646e-11, 5.14e-07, 3.68927339799e-11, 5.142e-07, 3.67970452757e-11, 5.144e-07, 3.67033110721e-11, 5.146e-07, 3.66115896591e-11, 5.148e-07, 3.65219390507e-11, 5.15e-07, 3.64344169599e-11, 5.152e-07, 3.63490807784e-11, 5.154e-07, 3.62659875583e-11, 5.156e-07, 3.61851939977e-11, 5.158e-07, 3.61067564293e-11, 5.16e-07, 3.60307308122e-11, 5.162e-07, 3.59571727261e-11, 5.164e-07, 3.58861373694e-11, 5.166e-07, 3.58176795588e-11, 5.168e-07, 3.57518537327e-11, 5.17e-07, 3.56887139567e-11, 5.172e-07, 3.56283139313e-11, 5.174e-07, 3.55707070028e-11, 5.176e-07, 3.55159461754e-11, 5.178e-07, 3.54640841267e-11, 5.18e-07, 3.54151732235e-11, 5.182e-07, 3.53692655414e-11, 5.184e-07, 3.53264128851e-11, 5.186e-07, 3.52866668103e-11, 5.188e-07, 3.5250078648e-11, 5.19e-07, 3.52166995292e-11, 5.192e-07, 3.5186580412e-11, 5.194e-07, 3.51597721089e-11, 5.196e-07, 3.51363253162e-11, 5.198e-07, 3.51162906437e-11, 5.2e-07, 3.50997186456e-11, 5.202e-07, 3.50866598518e-11, 5.204e-07, 3.50771648009e-11, 5.206e-07, 3.50712840722e-11, 5.208e-07, 3.50690683198e-11, 5.21e-07, 3.50705683059e-11, 5.212e-07, 3.50758349346e-11, 5.214e-07, 3.50849192864e-11, 5.216e-07, 3.50978726521e-11, 5.218e-07, 3.51147465669e-11, 5.22e-07, 3.51355928444e-11, 5.222e-07, 3.516046361e-11, 5.224e-07, 3.51894113348e-11, 5.226e-07, 3.52224888675e-11, 5.228e-07, 3.52597494676e-11, 5.23e-07, 3.53012468362e-11, 5.232e-07, 3.5347035147e-11, 5.234e-07, 3.5397169076e-11, 5.236e-07, 3.54517038308e-11, 5.238e-07, 3.55106951771e-11, 5.24e-07, 3.55741994663e-11, 5.242e-07, 3.56422736594e-11, 5.244e-07, 3.57149753511e-11, 5.246e-07, 3.57923627908e-11, 5.248e-07, 3.58744949032e-11, 5.25e-07, 3.59614313055e-11, 5.252e-07, 3.60532323236e-11, 5.254e-07, 3.61499590052e-11, 5.256e-07, 3.62516731311e-11, 5.258e-07, 3.63584372229e-11, 5.26e-07, 3.64703145491e-11, 5.262e-07, 3.65873691268e-11, 5.264e-07, 3.67096657213e-11, 5.266e-07, 3.68372698412e-11, 5.268e-07, 3.69702477303e-11, 5.27e-07, 3.71086663558e-11, 5.272e-07, 3.72525933911e-11, 5.274e-07, 3.74020971954e-11, 5.276e-07, 3.75572467877e-11, 5.278e-07, 3.77181118153e-11, 5.28e-07, 3.7884762518e-11, 5.282e-07, 3.80572696855e-11, 5.284e-07, 3.82357046086e-11, 5.286e-07, 3.84201390247e-11, 5.288e-07, 3.8610645055e-11, 5.29e-07, 3.8807295136e-11, 5.292e-07, 3.90101619416e-11, 5.294e-07, 3.92193182976e-11, 5.296e-07, 3.94348370882e-11, 5.298e-07, 3.96567911515e-11, 5.3e-07, 3.98852531672e-11, 5.302e-07, 4.01202955324e-11, 5.304e-07, 4.03619902278e-11, 5.306e-07, 4.06104086719e-11, 5.308e-07, 4.08656215632e-11, 5.31e-07, 4.11276987098e-11, 5.312e-07, 4.13967088466e-11, 5.314e-07, 4.16727194372e-11, 5.316e-07, 4.19557964632e-11, 5.318e-07, 4.22460041965e-11, 5.32e-07, 4.25434049575e-11, 5.322e-07, 4.28480588559e-11, 5.324e-07, 4.3160023515e-11, 5.326e-07, 4.34793537782e-11, 5.328e-07, 4.38061013969e-11, 5.33e-07, 4.41403147004e-11, 5.332e-07, 4.44820382452e-11, 5.334e-07, 4.48313124453e-11, 5.336e-07, 4.51881731817e-11, 5.338e-07, 4.55526513905e-11, 5.34e-07, 4.59247726303e-11, 5.342e-07, 4.6304556628e-11, 5.344e-07, 4.6692016802e-11, 5.346e-07, 4.7087159764e-11, 5.348e-07, 4.74899847989e-11, 5.35e-07, 4.79004833222e-11, 5.352e-07, 4.83186383161e-11, 5.354e-07, 4.87444237444e-11, 5.356e-07, 4.91778039461e-11, 5.358e-07, 4.961873301e-11, 5.36e-07, 5.00671541295e-11, 5.362e-07, 5.052299894e-11, 5.364e-07, 5.09861868401e-11, 5.366e-07, 5.14566242984e-11, 5.368e-07, 5.19342041473e-11, 5.37e-07, 5.24188048676e-11, 5.372e-07, 5.29102898647e-11, 5.374e-07, 5.34085067416e-11, 5.376e-07, 5.39132865699e-11, 5.378e-07, 5.44244431648e-11, 5.38e-07, 5.49417723664e-11, 5.382e-07, 5.5465051334e-11, 5.384e-07, 5.59940378559e-11, 5.386e-07, 5.65284696834e-11, 5.388e-07, 5.70680638919e-11, 5.39e-07, 5.76125162776e-11, 5.392e-07, 5.81615007956e-11, 5.394e-07, 5.87146690472e-11, 5.396e-07, 5.92716498232e-11, 5.398e-07, 5.98320487121e-11, 5.4e-07, 6.03954477801e-11, 5.402e-07, 6.09614053334e-11, 5.404e-07, 6.15294557686e-11, 5.406e-07, 6.2099109523e-11, 5.408e-07, 6.26698531305e-11, 5.41e-07, 6.32411493946e-11, 5.412e-07, 6.38124376851e-11, 5.414e-07, 6.43831343668e-11, 5.416e-07, 6.49526333692e-11, 5.418e-07, 6.55203069031e-11, 5.42e-07, 6.60855063308e-11, 5.422e-07, 6.66475631966e-11, 5.424e-07, 6.72057904203e-11, 5.426e-07, 6.77594836593e-11, 5.428e-07, 6.83079228395e-11, 5.43e-07, 6.88503738575e-11, 5.432e-07, 6.93860904513e-11, 5.434e-07, 6.9914316239e-11, 5.436e-07, 7.04342869192e-11, 5.438e-07, 7.09452326273e-11, 5.44e-07, 7.14463804407e-11, 5.442e-07, 7.19369570196e-11, 5.444e-07, 7.24161913742e-11, 5.446e-07, 7.28833177407e-11, 5.448e-07, 7.33375785521e-11, 5.45e-07, 7.37782274835e-11, 5.452e-07, 7.42045325532e-11, 5.454e-07, 7.46157792563e-11, 5.456e-07, 7.50112737086e-11, 5.458e-07, 7.53903457761e-11, 5.46e-07, 7.57523521646e-11, 5.462e-07, 7.60966794436e-11, 5.464e-07, 7.6422746978e-11, 5.466e-07, 7.67300097425e-11, 5.468e-07, 7.70179609915e-11, 5.47e-07, 7.72861347607e-11, 5.472e-07, 7.75341081765e-11, 5.474e-07, 7.77615035507e-11, 5.476e-07, 7.79679902405e-11, 5.478e-07, 7.81532862555e-11, 5.48e-07, 7.83171595968e-11, 5.482e-07, 7.84594293136e-11, 5.484e-07, 7.85799662698e-11, 5.486e-07, 7.86786936111e-11, 5.488e-07, 7.87555869315e-11, 5.49e-07, 7.88106741365e-11, 5.492e-07, 7.88440350076e-11, 5.494e-07, 7.8855800473e-11, 5.496e-07, 7.8846151594e-11, 5.498e-07, 7.88153182789e-11, 5.5e-07, 7.87635777395e-11, 5.502e-07, 7.86912527059e-11, 5.504e-07, 7.85987094206e-11, 5.506e-07, 7.84863554318e-11, 5.508e-07, 7.83546372081e-11, 5.51e-07, 7.82040375988e-11, 5.512e-07, 7.80350731647e-11, 5.514e-07, 7.78482914026e-11, 5.516e-07, 7.76442678897e-11, 5.518e-07, 7.74236033724e-11, 5.52e-07, 7.71869208232e-11, 5.522e-07, 7.69348624885e-11, 5.524e-07, 7.66680869513e-11, 5.526e-07, 7.63872662275e-11, 5.528e-07, 7.60930829166e-11, 5.53e-07, 7.57862274241e-11, 5.532e-07, 7.54673952715e-11, 5.534e-07, 7.5137284509e-11, 5.536e-07, 7.47965932417e-11, 5.538e-07, 7.4446017281e-11, 5.54e-07, 7.40862479299e-11, 5.542e-07, 7.37179699077e-11, 5.544e-07, 7.3341859421e-11, 5.546e-07, 7.29585823824e-11, 5.548e-07, 7.25687927807e-11, 5.55e-07, 7.21731312008e-11, 5.552e-07, 7.17722234947e-11, 5.554e-07, 7.13666795991e-11, 5.556e-07, 7.09570924981e-11, 5.558e-07, 7.05440373259e-11, 5.56e-07, 7.01280706043e-11, 5.562e-07, 6.97097296106e-11, 5.564e-07, 6.92895318679e-11, 5.566e-07, 6.88679747524e-11, 5.568e-07, 6.84455352106e-11, 5.57e-07, 6.80226695784e-11, 5.572e-07, 6.75998134953e-11, 5.574e-07, 6.71773819068e-11, 5.576e-07, 6.67557691467e-11, 5.578e-07, 6.63353490927e-11, 5.58e-07, 6.59164753877e-11, 5.582e-07, 6.54994817206e-11, 5.584e-07, 6.50846821597e-11, 5.586e-07, 6.46723715317e-11, 5.588e-07, 6.42628258411e-11, 5.59e-07, 6.38563027244e-11, 5.592e-07, 6.34530419325e-11, 5.594e-07, 6.30532658378e-11, 5.596e-07, 6.26571799604e-11, 5.598e-07, 6.2264973509e-11, 5.6e-07, 6.18768199336e-11, 5.602e-07, 6.14928774843e-11, 5.604e-07, 6.1113289776e-11, 5.606e-07, 6.07381863524e-11, 5.608e-07, 6.03676832497e-11, 5.61e-07, 6.0001883556e-11, 5.612e-07, 5.96408779646e-11, 5.614e-07, 5.92847453194e-11, 5.616e-07, 5.89335531511e-11, 5.618e-07, 5.85873582027e-11, 5.62e-07, 5.82462069421e-11, 5.622e-07, 5.79101360631e-11, 5.624e-07, 5.75791729719e-11, 5.626e-07, 5.72533362594e-11, 5.628e-07, 5.6932636159e-11, 5.63e-07, 5.66170749887e-11, 5.632e-07, 5.63066475789e-11, 5.634e-07, 5.60013416841e-11, 5.636e-07, 5.5701138379e-11, 5.638e-07, 5.54060124405e-11, 5.64e-07, 5.51159327133e-11, 5.642e-07, 5.48308624613e-11, 5.644e-07, 5.45507597048e-11, 5.646e-07, 5.42755775424e-11, 5.648e-07, 5.40052644607e-11, 5.65e-07, 5.37397646287e-11, 5.652e-07, 5.34790181812e-11, 5.654e-07, 5.32229614885e-11, 5.656e-07, 5.29715274144e-11, 5.658e-07, 5.27246455637e-11, 5.66e-07, 5.24822425169e-11, 5.662e-07, 5.2244242057e-11, 5.664e-07, 5.20105653842e-11, 5.666e-07, 5.17811313227e-11, 5.668e-07, 5.15558565182e-11, 5.67e-07, 5.13346556274e-11, 5.672e-07, 5.11174414992e-11, 5.674e-07, 5.09041253491e-11, 5.676e-07, 5.0694616927e-11, 5.678e-07, 5.04888246779e-11, 5.68e-07, 5.02866558975e-11, 5.682e-07, 5.00880168819e-11, 5.684e-07, 4.98928130723e-11, 5.686e-07, 4.97009491955e-11, 5.688e-07, 4.95123293994e-11, 5.69e-07, 4.93268573853e-11, 5.692e-07, 4.91444365358e-11, 5.694e-07, 4.89649700407e-11, 5.696e-07, 4.87883610182e-11, 5.698e-07, 4.86145126349e-11, 5.7e-07, 4.84433282223e-11, 5.702e-07, 4.82747113916e-11, 5.704e-07, 4.8108566146e-11, 5.706e-07, 4.79447969912e-11, 5.708e-07, 4.77833090446e-11, 5.71e-07, 4.76240081416e-11, 5.712e-07, 4.74668009419e-11, 5.714e-07, 4.73115950329e-11, 5.716e-07, 4.71582990329e-11, 5.718e-07, 4.70068226915e-11, 5.72e-07, 4.685707699e-11, 5.722e-07, 4.67089742396e-11, 5.724e-07, 4.65624281778e-11, 5.726e-07, 4.64173540646e-11, 5.728e-07, 4.62736687756e-11, 5.73e-07, 4.61312908946e-11, 5.732e-07, 4.59901408037e-11, 5.734e-07, 4.5850140772e-11, 5.736e-07, 4.57112150423e-11, 5.738e-07, 4.55732899148e-11, 5.74e-07, 4.54362938299e-11, 5.742e-07, 4.53001574475e-11, 5.744e-07, 4.51648137238e-11, 5.746e-07, 4.50301979855e-11, 5.748e-07, 4.4896248001e-11, 5.75e-07, 4.47629040483e-11, 5.752e-07, 4.46301089793e-11, 5.754e-07, 4.44978082811e-11, 5.756e-07, 4.4365950133e-11, 5.758e-07, 4.42344854597e-11, 5.76e-07, 4.41033679809e-11, 5.762e-07, 4.39725542552e-11, 5.764e-07, 4.38420037217e-11, 5.766e-07, 4.37116787347e-11, 5.768e-07, 4.35815445955e-11, 5.77e-07, 4.34515695782e-11, 5.772e-07, 4.33217249508e-11, 5.774e-07, 4.31919849919e-11, 5.776e-07, 4.30623270007e-11, 5.778e-07, 4.29327313035e-11, 5.78e-07, 4.28031812536e-11, 5.782e-07, 4.2673663227e-11, 5.784e-07, 4.25441666113e-11, 5.786e-07, 4.24146837912e-11, 5.788e-07, 4.22852101272e-11, 5.79e-07, 4.21557439299e-11, 5.792e-07, 4.20262864287e-11, 5.794e-07, 4.1896841736e-11, 5.796e-07, 4.17674168062e-11, 5.798e-07, 4.16380213897e-11, 5.8e-07, 4.1508667983e-11, 5.802e-07, 4.13793717733e-11, 5.804e-07, 4.12501505803e-11, 5.806e-07, 4.11210247922e-11, 5.808e-07, 4.09920172998e-11, 5.81e-07, 4.08631534254e-11, 5.812e-07, 4.07344608495e-11, 5.814e-07, 4.06059695336e-11, 5.816e-07, 4.04777116413e-11, 5.818e-07, 4.03497214556e-11, 5.82e-07, 4.02220352955e-11, 5.822e-07, 4.00946914288e-11, 5.824e-07, 3.99677299856e-11, 5.826e-07, 3.98411928681e-11, 5.828e-07, 3.97151236616e-11, 5.83e-07, 3.9589567543e-11, 5.832e-07, 3.94645711902e-11, 5.834e-07, 3.93401826905e-11, 5.836e-07, 3.92164514496e-11, 5.838e-07, 3.90934281013e-11, 5.84e-07, 3.89711644171e-11, 5.842e-07, 3.88497132177e-11, 5.844e-07, 3.87291282852e-11, 5.846e-07, 3.8609464277e-11, 5.848e-07, 3.84907766414e-11, 5.85e-07, 3.83731215349e-11, 5.852e-07, 3.82565557423e-11, 5.854e-07, 3.81411365981e-11, 5.856e-07, 3.80269219116e-11, 5.858e-07, 3.79139698933e-11, 5.86e-07, 3.78023390859e-11, 5.862e-07, 3.76920882962e-11, 5.864e-07, 3.75832765317e-11, 5.866e-07, 3.74759629395e-11, 5.868e-07, 3.73702067491e-11, 5.87e-07, 3.72660672173e-11, 5.872e-07, 3.7163603578e-11, 5.874e-07, 3.70628749946e-11, 5.876e-07, 3.69639405155e-11, 5.878e-07, 3.68668590341e-11, 5.88e-07, 3.67716892513e-11, 5.882e-07, 3.66784896419e-11, 5.884e-07, 3.65873184244e-11, 5.886e-07, 3.64982335341e-11, 5.888e-07, 3.64112925999e-11, 5.89e-07, 3.63265529239e-11, 5.892e-07, 3.62440714643e-11, 5.894e-07, 3.61639048223e-11, 5.896e-07, 3.60861092309e-11, 5.898e-07, 3.60107405479e-11, 5.9e-07, 3.59378542507e-11, 5.902e-07, 3.5867505435e-11, 5.904e-07, 3.57997488157e-11, 5.906e-07, 3.57346387303e-11, 5.908e-07, 3.56722291456e-11, 5.91e-07, 3.5612573666e-11, 5.912e-07, 3.55557255446e-11, 5.914e-07, 3.55017376963e-11, 5.916e-07, 3.54506627135e-11, 5.918e-07, 3.54025528831e-11, 5.92e-07, 3.53574602058e-11, 5.922e-07, 3.53154364172e-11, 5.924e-07, 3.52765330102e-11, 5.926e-07, 3.52408012597e-11, 5.928e-07, 3.52082922476e-11, 5.93e-07, 3.51790568901e-11, 5.932e-07, 3.51531459657e-11, 5.934e-07, 3.51306101445e-11, 5.936e-07, 3.51115000181e-11, 5.938e-07, 3.50958661313e-11, 5.94e-07, 3.5083759013e-11, 5.942e-07, 3.50752292095e-11, 5.944e-07, 3.5070327317e-11, 5.946e-07, 3.50691040151e-11, 5.948e-07, 3.50716101009e-11, 5.95e-07, 3.50778965224e-11, 5.952e-07, 3.50880144134e-11, 5.954e-07, 3.51020151267e-11, 5.956e-07, 3.51199502691e-11, 5.958e-07, 3.51418717345e-11, 5.96e-07, 3.51678317379e-11, 5.962e-07, 3.51978828485e-11, 5.964e-07, 3.52320780223e-11, 5.966e-07, 3.52704706341e-11, 5.968e-07, 3.53131145089e-11, 5.97e-07, 3.53600639524e-11, 5.972e-07, 3.54113737806e-11, 5.974e-07, 3.54670993481e-11, 5.976e-07, 3.55272965754e-11, 5.978e-07, 3.55920219751e-11, 5.98e-07, 3.56613326761e-11, 5.982e-07, 3.57352864468e-11, 5.984e-07, 3.5813941716e-11, 5.986e-07, 3.58973575926e-11, 5.988e-07, 3.59855938826e-11, 5.99e-07, 3.60787111045e-11, 5.992e-07, 3.61767705017e-11, 5.994e-07, 3.62798340533e-11, 5.996e-07, 3.63879644809e-11, 5.998e-07, 3.65012252539e-11, 6e-07, 3.66196805904e-11, 6.002e-07, 3.67433954559e-11, 6.004e-07, 3.68724355573e-11, 6.006e-07, 3.7006867334e-11, 6.008e-07, 3.71467579445e-11, 6.01e-07, 3.72921752486e-11, 6.012e-07, 3.74431877853e-11, 6.014e-07, 3.75998647455e-11, 6.016e-07, 3.77622759396e-11, 6.018e-07, 3.79304917591e-11, 6.02e-07, 3.81045831335e-11, 6.022e-07, 3.8284621479e-11, 6.024e-07, 3.84706786425e-11, 6.026e-07, 3.8662826837e-11, 6.028e-07, 3.88611385706e-11, 6.03e-07, 3.90656865666e-11, 6.032e-07, 3.92765436764e-11, 6.034e-07, 3.94937827821e-11, 6.036e-07, 3.97174766909e-11, 6.038e-07, 3.99476980192e-11, 6.04e-07, 4.01845190661e-11, 6.042e-07, 4.04280116761e-11, 6.044e-07, 4.06782470903e-11, 6.046e-07, 4.09352957855e-11, 6.048e-07, 4.11992273004e-11, 6.05e-07, 4.14701100485e-11, 6.052e-07, 4.1748011117e-11, 6.054e-07, 4.20329960513e-11, 6.056e-07, 4.23251286241e-11, 6.058e-07, 4.26244705885e-11, 6.06e-07, 4.29310814145e-11, 6.062e-07, 4.32450180088e-11, 6.064e-07, 4.35663344161e-11, 6.066e-07, 4.38950815024e-11, 6.068e-07, 4.42313066196e-11, 6.07e-07, 4.45750532492e-11, 6.072e-07, 4.49263606278e-11, 6.074e-07, 4.52852633501e-11, 6.076e-07, 4.56517909522e-11, 6.078e-07, 4.60259674727e-11, 6.08e-07, 4.64078109928e-11, 6.082e-07, 4.67973331535e-11, 6.084e-07, 4.71945386519e-11, 6.086e-07, 4.75994247144e-11, 6.088e-07, 4.80119805492e-11, 6.09e-07, 4.84321867758e-11, 6.092e-07, 4.88600148347e-11, 6.094e-07, 4.92954263758e-11, 6.096e-07, 4.97383726271e-11, 6.098e-07, 5.01887937451e-11, 6.1e-07, 5.06466181478e-11, 6.102e-07, 5.11117618317e-11, 6.104e-07, 5.15841276744e-11, 6.106e-07, 5.20636047267e-11, 6.108e-07, 5.25500674938e-11, 6.11e-07, 5.30433752107e-11, 6.112e-07, 5.35433711141e-11, 6.114e-07, 5.40498817146e-11, 6.116e-07, 5.45627160722e-11, 6.118e-07, 5.50816650811e-11, 6.12e-07, 5.56065007677e-11, 6.122e-07, 5.6136975606e-11, 6.124e-07, 5.66728218584e-11, 6.126e-07, 5.72137509459e-11, 6.128e-07, 5.7759452855e-11, 6.13e-07, 5.83095955884e-11, 6.132e-07, 5.88638246665e-11, 6.134e-07, 5.94217626874e-11, 6.136e-07, 5.99830089535e-11, 6.138e-07, 6.05471391728e-11, 6.14e-07, 6.1113705244e-11, 6.142e-07, 6.16822351328e-11, 6.144e-07, 6.22522328497e-11, 6.146e-07, 6.28231785366e-11, 6.148e-07, 6.3394528672e-11, 6.15e-07, 6.39657164025e-11, 6.152e-07, 6.45361520087e-11, 6.154e-07, 6.51052235131e-11, 6.156e-07, 6.56722974382e-11, 6.158e-07, 6.62367197185e-11, 6.16e-07, 6.67978167746e-11, 6.162e-07, 6.73548967518e-11, 6.164e-07, 6.79072509272e-11, 6.166e-07, 6.84541552864e-11, 6.168e-07, 6.89948722716e-11, 6.17e-07, 6.95286526972e-11, 6.172e-07, 7.00547378328e-11, 6.174e-07, 7.05723616458e-11, 6.176e-07, 7.10807531991e-11, 6.178e-07, 7.15791391932e-11, 6.18e-07, 7.20667466427e-11, 6.182e-07, 7.25428056739e-11, 6.184e-07, 7.30065524283e-11, 6.186e-07, 7.34572320548e-11, 6.188e-07, 7.38941017727e-11, 6.19e-07, 7.4316433983e-11, 6.192e-07, 7.47235194077e-11, 6.194e-07, 7.5114670232e-11, 6.196e-07, 7.54892232255e-11, 6.198e-07, 7.58465428168e-11, 6.2e-07, 7.61860240956e-11, 6.202e-07, 7.65070957151e-11, 6.204e-07, 7.68092226698e-11, 6.206e-07, 7.70919089234e-11, 6.208e-07, 7.73546998604e-11, 6.21e-07, 7.75971845403e-11, 6.212e-07, 7.78189977313e-11, 6.214e-07, 7.80198217036e-11, 6.216e-07, 7.81993877665e-11, 6.218e-07, 7.83574775324e-11, 6.22e-07, 7.84939238966e-11, 6.222e-07, 7.86086117237e-11, 6.224e-07, 7.87014782349e-11, 6.226e-07, 7.87725130924e-11, 6.228e-07, 7.88217581821e-11, 6.23e-07, 7.88493070989e-11, 6.232e-07, 7.88553043395e-11, 6.234e-07, 7.88399442148e-11, 6.236e-07, 7.88034694932e-11, 6.238e-07, 7.87461697897e-11, 6.24e-07, 7.86683797207e-11, 6.242e-07, 7.85704768412e-11, 6.244e-07, 7.84528793879e-11, 6.246e-07, 7.83160438505e-11, 6.248e-07, 7.81604623949e-11, 6.25e-07, 7.79866601623e-11, 6.252e-07, 7.77951924705e-11, 6.254e-07, 7.75866419408e-11, 6.256e-07, 7.73616155755e-11, 6.258e-07, 7.71207418106e-11, 6.26e-07, 7.68646675652e-11, 6.262e-07, 7.65940553114e-11, 6.264e-07, 7.63095801832e-11, 6.266e-07, 7.60119271449e-11, 6.268e-07, 7.57017882355e-11, 6.27e-07, 7.53798599047e-11, 6.272e-07, 7.50468404554e-11, 6.274e-07, 7.47034276021e-11, 6.276e-07, 7.43503161579e-11, 6.278e-07, 7.39881958561e-11, 6.28e-07, 7.36177493144e-11, 6.282e-07, 7.32396501445e-11, 6.284e-07, 7.28545612123e-11, 6.286e-07, 7.24631330473e-11, 6.288e-07, 7.2066002404e-11, 6.29e-07, 7.16637909722e-11, 6.292e-07, 7.12571042338e-11, 6.294e-07, 7.08465304638e-11, 6.296e-07, 7.04326398694e-11, 6.298e-07, 7.00159838634e-11, 6.3e-07, 6.95970944654e-11, 6.302e-07, 6.91764838243e-11, 6.304e-07, 6.87546438555e-11, 6.306e-07, 6.83320459867e-11, 6.308e-07, 6.79091410025e-11, 6.31e-07, 6.74863589839e-11, 6.312e-07, 6.70641093322e-11, 6.314e-07, 6.66427808719e-11, 6.316e-07, 6.62227420245e-11, 6.318e-07, 6.58043410467e-11, 6.32e-07, 6.53879063259e-11, 6.322e-07, 6.49737467261e-11, 6.324e-07, 6.45621519788e-11, 6.326e-07, 6.41533931119e-11, 6.328e-07, 6.37477229122e-11, 6.33e-07, 6.33453764152e-11, 6.332e-07, 6.2946571417e-11, 6.334e-07, 6.25515090054e-11, 6.336e-07, 6.21603741044e-11, 6.338e-07, 6.17733360285e-11, 6.34e-07, 6.1390549044e-11, 6.342e-07, 6.10121529327e-11, 6.344e-07, 6.06382735576e-11, 6.346e-07, 6.02690234242e-11, 6.348e-07, 5.99045022395e-11, 6.35e-07, 5.95447974627e-11, 6.352e-07, 5.91899848486e-11, 6.354e-07, 5.88401289812e-11, 6.356e-07, 5.8495283795e-11, 6.358e-07, 5.81554930859e-11, 6.36e-07, 5.78207910074e-11, 6.362e-07, 5.74912025534e-11, 6.364e-07, 5.71667440271e-11, 6.366e-07, 5.68474234943e-11, 6.368e-07, 5.65332412218e-11, 6.37e-07, 5.62241901006e-11, 6.372e-07, 5.5920256054e-11, 6.374e-07, 5.56214184292e-11, 6.376e-07, 5.53276503754e-11, 6.378e-07, 5.50389192052e-11, 6.38e-07, 5.47551867427e-11, 6.382e-07, 5.44764096558e-11, 6.384e-07, 5.42025397753e-11, 6.386e-07, 5.39335244003e-11, 6.388e-07, 5.36693065897e-11, 6.39e-07, 5.34098254418e-11, 6.392e-07, 5.31550163607e-11, 6.394e-07, 5.29048113117e-11, 6.396e-07, 5.26591390648e-11, 6.398e-07, 5.24179254282e-11, 6.4e-07, 5.21810934704e-11, 6.402e-07, 5.19485637342e-11, 6.404e-07, 5.17202544398e-11, 6.406e-07, 5.14960816808e-11, 6.408e-07, 5.12759596111e-11, 6.41e-07, 5.10598006242e-11, 6.412e-07, 5.08475155262e-11, 6.414e-07, 5.06390137011e-11, 6.416e-07, 5.04342032703e-11, 6.418e-07, 5.02329912466e-11, 6.42e-07, 5.00352836827e-11, 6.422e-07, 4.98409858145e-11, 6.424e-07, 4.96500022002e-11, 6.426e-07, 4.94622368549e-11, 6.428e-07, 4.92775933819e-11, 6.43e-07, 4.90959751001e-11, 6.432e-07, 4.8917285168e-11, 6.434e-07, 4.87414267053e-11, 6.436e-07, 4.85683029114e-11, 6.438e-07, 4.83978171818e-11, 6.44e-07, 4.82298732219e-11, 6.442e-07, 4.8064375159e-11, 6.444e-07, 4.79012276525e-11, 6.446e-07, 4.7740336002e-11, 6.448e-07, 4.75816062539e-11, 6.45e-07, 4.74249453068e-11, 6.452e-07, 4.72702610148e-11, 6.454e-07, 4.71174622899e-11, 6.456e-07, 4.69664592028e-11, 6.458e-07, 4.68171630821e-11, 6.46e-07, 4.66694866124e-11, 6.462e-07, 4.65233439306e-11, 6.464e-07, 4.63786507213e-11, 6.466e-07, 4.62353243096e-11, 6.468e-07, 4.60932837531e-11, 6.47e-07, 4.59524499321e-11, 6.472e-07, 4.5812745637e-11, 6.474e-07, 4.56740956546e-11, 6.476e-07, 4.55364268518e-11, 6.478e-07, 4.5399668257e-11, 6.48e-07, 4.52637511391e-11, 6.482e-07, 4.51286090834e-11, 6.484e-07, 4.49941780653e-11, 6.486e-07, 4.48603965202e-11, 6.488e-07, 4.47272054109e-11, 6.49e-07, 4.45945482909e-11, 6.492e-07, 4.44623713645e-11, 6.494e-07, 4.43306235429e-11, 6.496e-07, 4.41992564965e-11, 6.498e-07, 4.40682247027e-11, 6.5e-07, 4.39374854897e-11, 6.502e-07, 4.38069990756e-11, 6.504e-07, 4.36767286032e-11, 6.506e-07, 4.35466401693e-11, 6.508e-07, 4.34167028499e-11, 6.51e-07, 4.32868887197e-11, 6.512e-07, 4.31571728672e-11, 6.514e-07, 4.30275334041e-11, 6.516e-07, 4.28979514692e-11, 6.518e-07, 4.2768411228e-11, 6.52e-07, 4.26388998661e-11, 6.522e-07, 4.25094075774e-11, 6.524e-07, 4.23799275478e-11, 6.526e-07, 4.22504559322e-11, 6.528e-07, 4.21209918281e-11, 6.53e-07, 4.19915372427e-11, 6.532e-07, 4.18620970553e-11, 6.534e-07, 4.17326789756e-11, 6.536e-07, 4.16032934963e-11, 6.538e-07, 4.14739538418e-11, 6.54e-07, 4.13446759118e-11, 6.542e-07, 4.12154782219e-11, 6.544e-07, 4.10863818389e-11, 6.546e-07, 4.09574103132e-11, 6.548e-07, 4.08285896075e-11, 6.55e-07, 4.06999480224e-11, 6.552e-07, 4.05715161183e-11, 6.554e-07, 4.0443326636e-11, 6.556e-07, 4.03154144133e-11, 6.558e-07, 4.01878163009e-11, 6.56e-07, 4.00605710751e-11, 6.562e-07, 3.99337193506e-11, 6.564e-07, 3.98073034902e-11, 6.566e-07, 3.96813675154e-11, 6.568e-07, 3.9555957015e-11, 6.57e-07, 3.94311190542e-11, 6.572e-07, 3.93069020831e-11, 6.574e-07, 3.9183355846e-11, 6.576e-07, 3.90605312907e-11, 6.578e-07, 3.89384804792e-11, 6.58e-07, 3.88172564989e-11, 6.582e-07, 3.8696913375e-11, 6.584e-07, 3.85775059857e-11, 6.586e-07, 3.84590899772e-11, 6.588e-07, 3.83417216825e-11, 6.59e-07, 3.82254580416e-11, 6.592e-07, 3.81103565238e-11, 6.594e-07, 3.79964750529e-11, 6.596e-07, 3.78838719356e-11, 6.598e-07, 3.77726057917e-11, 6.6e-07, 3.76627354882e-11, 6.602e-07, 3.75543200759e-11, 6.604e-07, 3.74474187296e-11, 6.606e-07, 3.73420906912e-11, 6.608e-07, 3.72383952162e-11, 6.61e-07, 3.71363915242e-11, 6.612e-07, 3.70361387518e-11, 6.614e-07, 3.69376959098e-11, 6.616e-07, 3.68411218432e-11, 6.618e-07, 3.67464751955e-11, 6.62e-07, 3.66538143756e-11, 6.622e-07, 3.65631975283e-11, 6.624e-07, 3.6474682509e-11, 6.626e-07, 3.63883268606e-11, 6.628e-07, 3.63041877943e-11, 6.63e-07, 3.62223221739e-11, 6.632e-07, 3.61427865026e-11, 6.634e-07, 3.60656369134e-11, 6.636e-07, 3.5990929162e-11, 6.638e-07, 3.59187186237e-11, 6.64e-07, 3.58490602917e-11, 6.642e-07, 3.57820087791e-11, 6.644e-07, 3.57176183231e-11, 6.646e-07, 3.56559427924e-11, 6.648e-07, 3.55970356959e-11, 6.65e-07, 3.55409501944e-11, 6.652e-07, 3.54877391148e-11, 6.654e-07, 3.54374549656e-11, 6.656e-07, 3.53901499549e-11, 6.658e-07, 3.53458760102e-11, 6.66e-07, 3.53046847996e-11, 6.662e-07, 3.52666277551e-11, 6.664e-07, 3.52317560971e-11, 6.666e-07, 3.52001208605e-11, 6.668e-07, 3.51717729215e-11, 6.67e-07, 3.51467630268e-11, 6.672e-07, 3.51251418223e-11, 6.674e-07, 3.51069598841e-11, 6.676e-07, 3.50922677494e-11, 6.678e-07, 3.50811159487e-11, 6.68e-07, 3.50735550384e-11, 6.682e-07, 3.50696356337e-11, 6.684e-07, 3.50694084425e-11, 6.686e-07, 3.5072924299e-11, 6.688e-07, 3.50802341979e-11, 6.69e-07, 3.50913893281e-11, 6.692e-07, 3.51064411076e-11, 6.694e-07, 3.51254412167e-11, 6.696e-07, 3.51484416324e-11, 6.698e-07, 3.51754946614e-11, 6.7e-07, 3.52066529736e-11, 6.702e-07, 3.52419696343e-11, 6.704e-07, 3.52814981362e-11, 6.706e-07, 3.53252924302e-11, 6.708e-07, 3.53734069563e-11, 6.71e-07, 3.54258966722e-11, 6.712e-07, 3.54828170818e-11, 6.714e-07, 3.55442242622e-11, 6.716e-07, 3.56101748889e-11, 6.718e-07, 3.56807262603e-11, 6.72e-07, 3.57559363202e-11, 6.722e-07, 3.58358636781e-11, 6.724e-07, 3.59205676283e-11, 6.726e-07, 3.60101081669e-11, 6.728e-07, 3.61045460055e-11, 6.73e-07, 3.62039425845e-11, 6.732e-07, 3.63083600813e-11, 6.734e-07, 3.64178614182e-11, 6.736e-07, 3.65325102654e-11, 6.738e-07, 3.66523710421e-11, 6.74e-07, 3.67775089134e-11, 6.742e-07, 3.69079897839e-11, 6.744e-07, 3.70438802876e-11, 6.746e-07, 3.7185247773e-11, 6.748e-07, 3.73321602848e-11, 6.75e-07, 3.74846865398e-11, 6.752e-07, 3.76428958987e-11, 6.754e-07, 3.78068583317e-11, 6.756e-07, 3.79766443794e-11, 6.758e-07, 3.81523251071e-11, 6.76e-07, 3.83339720525e-11, 6.762e-07, 3.85216571674e-11, 6.764e-07, 3.87154527513e-11, 6.766e-07, 3.89154313782e-11, 6.768e-07, 3.91216658149e-11, 6.77e-07, 3.93342289307e-11, 6.772e-07, 3.95531935985e-11, 6.774e-07, 3.97786325862e-11, 6.776e-07, 4.00106184377e-11, 6.778e-07, 4.0249223344e-11, 6.78e-07, 4.04945190029e-11, 6.782e-07, 4.07465764667e-11, 6.784e-07, 4.10054659777e-11, 6.786e-07, 4.12712567917e-11, 6.788e-07, 4.15440169865e-11, 6.79e-07, 4.18238132571e-11, 6.792e-07, 4.21107106966e-11, 6.794e-07, 4.24047725603e-11, 6.796e-07, 4.27060600149e-11, 6.798e-07, 4.30146318708e-11, 6.8e-07, 4.33305442963e-11, 6.802e-07, 4.36538505148e-11, 6.804e-07, 4.39846004829e-11, 6.806e-07, 4.4322840549e-11, 6.808e-07, 4.4668613093e-11, 6.81e-07, 4.50219561452e-11, 6.812e-07, 4.53829029842e-11, 6.814e-07, 4.57514817143e-11, 6.816e-07, 4.61277148211e-11, 6.818e-07, 4.65116187052e-11, 6.82e-07, 4.69032031941e-11, 6.822e-07, 4.7302471032e-11, 6.824e-07, 4.77094173478e-11, 6.826e-07, 4.81240291008e-11, 6.828e-07, 4.85462845055e-11, 6.83e-07, 4.89761524352e-11, 6.832e-07, 4.94135918048e-11, 6.834e-07, 4.98585509349e-11, 6.836e-07, 5.03109668972e-11, 6.838e-07, 5.0770764843e-11, 6.84e-07, 5.1237857316e-11, 6.842e-07, 5.17121435524e-11, 6.844e-07, 5.21935087692e-11, 6.846e-07, 5.26818234438e-11, 6.848e-07, 5.31769425885e-11, 6.85e-07, 5.36787050212e-11, 6.852e-07, 5.4186932639e-11, 6.854e-07, 5.47014296954e-11, 6.856e-07, 5.52219820881e-11, 6.858e-07, 5.57483566611e-11, 6.86e-07, 5.62803005266e-11, 6.862e-07, 5.68175404127e-11, 6.864e-07, 5.73597820433e-11, 6.866e-07, 5.79067095555e-11, 6.868e-07, 5.84579849636e-11, 6.87e-07, 5.90132476754e-11, 6.872e-07, 5.95721140693e-11, 6.874e-07, 6.01341771401e-11, 6.876e-07, 6.0699006222e-11, 6.878e-07, 6.12661467973e-11, 6.88e-07, 6.18351203991e-11, 6.882e-07, 6.24054246173e-11, 6.884e-07, 6.29765332166e-11, 6.886e-07, 6.35478963743e-11, 6.888e-07, 6.41189410474e-11, 6.89e-07, 6.46890714758e-11, 6.892e-07, 6.52576698299e-11, 6.894e-07, 6.58240970094e-11, 6.896e-07, 6.63876935985e-11, 6.898e-07, 6.69477809833e-11, 6.9e-07, 6.75036626359e-11, 6.902e-07, 6.80546255667e-11, 6.904e-07, 6.85999419472e-11, 6.906e-07, 6.9138870903e-11, 6.908e-07, 6.96706604752e-11, 6.91e-07, 7.01945497463e-11, 6.912e-07, 7.07097711257e-11, 6.914e-07, 7.12155527867e-11, 6.916e-07, 7.1711121246e-11, 6.918e-07, 7.21957040742e-11, 6.92e-07, 7.2668532723e-11, 6.922e-07, 7.31288454549e-11, 6.924e-07, 7.35758903558e-11, 6.926e-07, 7.40089284132e-11, 6.928e-07, 7.44272366373e-11, 6.93e-07, 7.48301112036e-11, 6.932e-07, 7.52168705915e-11, 6.934e-07, 7.5586858696e-11, 6.936e-07, 7.59394478853e-11, 6.938e-07, 7.62740419783e-11, 6.94e-07, 7.65900791165e-11, 6.942e-07, 7.68870345043e-11, 6.944e-07, 7.71644229911e-11, 6.946e-07, 7.74218014729e-11, 6.948e-07, 7.7658771089e-11, 6.95e-07, 7.78749791931e-11, 6.952e-07, 7.80701210796e-11, 6.954e-07, 7.82439414484e-11, 6.956e-07, 7.83962355938e-11, 6.958e-07, 7.85268503066e-11, 6.96e-07, 7.86356844805e-11, 6.962e-07, 7.87226894179e-11, 6.964e-07, 7.87878688335e-11, 6.966e-07, 7.88312785568e-11, 6.968e-07, 7.88530259375e-11, 6.97e-07, 7.88532689626e-11, 6.972e-07, 7.88322150947e-11, 6.974e-07, 7.87901198459e-11, 6.976e-07, 7.87272851017e-11, 6.978e-07, 7.86440572159e-11, 6.98e-07, 7.8540824893e-11, 6.982e-07, 7.84180168833e-11, 6.984e-07, 7.8276099512e-11, 6.986e-07, 7.81155740664e-11, 6.988e-07, 7.79369740666e-11, 6.99e-07, 7.77408624441e-11, 6.992e-07, 7.75278286535e-11, 6.994e-07, 7.72984857406e-11, 6.996e-07, 7.70534673921e-11, 6.998e-07, 7.67934249887e-11, 7e-07, 7.6519024683e-11, 7.002e-07, 7.62309445231e-11, 7.004e-07, 7.59298716394e-11, 7.006e-07, 7.56164995122e-11, 7.008e-07, 7.52915253353e-11, 7.01e-07, 7.49556474881e-11, 7.012e-07, 7.4609563128e-11, 7.014e-07, 7.42539659125e-11, 7.016e-07, 7.38895438588e-11, 7.018e-07, 7.35169773465e-11, 7.02e-07, 7.31369372673e-11, 7.022e-07, 7.27500833253e-11, 7.024e-07, 7.23570624876e-11, 7.026e-07, 7.19585075852e-11, 7.028e-07, 7.15550360631e-11, 7.03e-07, 7.11472488768e-11, 7.032e-07, 7.07357295298e-11, 7.034e-07, 7.03210432504e-11, 7.036e-07, 6.99037362991e-11, 7.038e-07, 6.94843354034e-11, 7.04e-07, 6.90633473118e-11, 7.042e-07, 6.86412584609e-11, 7.044e-07, 6.8218534748e-11, 7.046e-07, 6.77956214026e-11, 7.048e-07, 6.73729429487e-11, 7.05e-07, 6.69509032508e-11, 7.052e-07, 6.65298856367e-11, 7.054e-07, 6.6110253089e-11, 7.056e-07, 6.56923484996e-11, 7.058e-07, 6.5276494979e-11, 7.06e-07, 6.48629962154e-11, 7.062e-07, 6.44521368759e-11, 7.064e-07, 6.40441830453e-11, 7.066e-07, 6.36393826962e-11, 7.068e-07, 6.3237966185e-11, 7.07e-07, 6.28401467702e-11, 7.072e-07, 6.24461211467e-11, 7.074e-07, 6.20560699935e-11, 7.076e-07, 6.16701585302e-11, 7.078e-07, 6.12885370795e-11, 7.08e-07, 6.09113416317e-11, 7.082e-07, 6.05386944089e-11, 7.084e-07, 6.01707044265e-11, 7.086e-07, 5.98074680499e-11, 7.088e-07, 5.94490695435e-11, 7.09e-07, 5.90955816115e-11, 7.092e-07, 5.87470659283e-11, 7.094e-07, 5.84035736576e-11, 7.096e-07, 5.80651459584e-11, 7.098e-07, 5.77318144787e-11, 7.1e-07, 5.74036018342e-11, 7.102e-07, 5.70805220728e-11, 7.104e-07, 5.67625811245e-11, 7.106e-07, 5.64497772352e-11, 7.108e-07, 5.61421013861e-11, 7.11e-07, 5.58395376973e-11, 7.112e-07, 5.5542063816e-11, 7.114e-07, 5.52496512895e-11, 7.116e-07, 5.49622659238e-11, 7.118e-07, 5.46798681265e-11, 7.12e-07, 5.44024132364e-11, 7.122e-07, 5.41298518386e-11, 7.124e-07, 5.38621300657e-11, 7.126e-07, 5.35991898867e-11, 7.128e-07, 5.33409693822e-11, 7.13e-07, 5.3087403009e-11, 7.132e-07, 5.28384218509e-11, 7.134e-07, 5.25939538607e-11, 7.136e-07, 5.23539240893e-11, 7.138e-07, 5.21182549071e-11, 7.14e-07, 5.18868662134e-11, 7.142e-07, 5.1659675639e-11, 7.144e-07, 5.14365987386e-11, 7.146e-07, 5.12175491762e-11, 7.148e-07, 5.10024389027e-11, 7.15e-07, 5.07911783262e-11, 7.152e-07, 5.05836764766e-11, 7.154e-07, 5.03798411627e-11, 7.156e-07, 5.01795791253e-11, 7.158e-07, 4.99827961838e-11, 7.16e-07, 4.97893973789e-11, 7.162e-07, 4.95992871097e-11, 7.164e-07, 4.94123692684e-11, 7.166e-07, 4.92285473693e-11, 7.168e-07, 4.90477246762e-11, 7.17e-07, 4.88698043255e-11, 7.172e-07, 4.86946894466e-11, 7.174e-07, 4.85222832803e-11, 7.176e-07, 4.83524892942e-11, 7.178e-07, 4.81852112961e-11, 7.18e-07, 4.80203535453e-11, 7.182e-07, 4.78578208625e-11, 7.184e-07, 4.76975187374e-11, 7.186e-07, 4.75393534349e-11, 7.188e-07, 4.73832321e-11, 7.19e-07, 4.72290628607e-11, 7.192e-07, 4.70767549304e-11, 7.194e-07, 4.69262187075e-11, 7.196e-07, 4.67773658752e-11, 7.198e-07, 4.66301094986e-11, 7.2e-07, 4.64843641206e-11, 7.202e-07, 4.63400458572e-11, 7.204e-07, 4.61970724897e-11, 7.206e-07, 4.60553635562e-11, 7.208e-07, 4.59148404411e-11, 7.21e-07, 4.57754264623e-11, 7.212e-07, 4.5637046957e-11, 7.214e-07, 4.54996293643e-11, 7.216e-07, 4.53631033065e-11, 7.218e-07, 4.52274006669e-11, 7.22e-07, 4.50924556654e-11, 7.222e-07, 4.49582049308e-11, 7.224e-07, 4.48245875706e-11, 7.226e-07, 4.4691545237e-11, 7.228e-07, 4.45590221893e-11, 7.23e-07, 4.44269653531e-11, 7.232e-07, 4.42953243752e-11, 7.234e-07, 4.41640516751e-11, 7.236e-07, 4.40331024912e-11, 7.238e-07, 4.3902434924e-11, 7.24e-07, 4.37720099735e-11, 7.242e-07, 4.36417915725e-11, 7.244e-07, 4.35117466155e-11, 7.246e-07, 4.33818449816e-11, 7.248e-07, 4.32520595534e-11, 7.25e-07, 4.31223662302e-11, 7.252e-07, 4.2992743936e-11, 7.254e-07, 4.28631746224e-11, 7.256e-07, 4.27336432666e-11, 7.258e-07, 4.26041378629e-11, 7.26e-07, 4.24746494104e-11, 7.262e-07, 4.23451718943e-11, 7.264e-07, 4.22157022623e-11, 7.266e-07, 4.20862403963e-11, 7.268e-07, 4.19567890784e-11, 7.27e-07, 4.18273539521e-11, 7.272e-07, 4.16979434789e-11, 7.274e-07, 4.156856889e-11, 7.276e-07, 4.14392441337e-11, 7.278e-07, 4.1309985818e-11, 7.28e-07, 4.11808131497e-11, 7.282e-07, 4.10517478691e-11, 7.284e-07, 4.09228141813e-11, 7.286e-07, 4.07940386841e-11, 7.288e-07, 4.06654502923e-11, 7.29e-07, 4.05370801598e-11, 7.292e-07, 4.04089615983e-11, 7.294e-07, 4.02811299945e-11, 7.296e-07, 4.01536227244e-11, 7.298e-07, 4.00264790667e-11, 7.3e-07, 3.98997401139e-11, 7.302e-07, 3.97734486833e-11, 7.304e-07, 3.96476492258e-11, 7.306e-07, 3.95223877355e-11, 7.308e-07, 3.93977116584e-11, 7.31e-07, 3.92736698009e-11, 7.312e-07, 3.91503122392e-11, 7.314e-07, 3.9027690229e-11, 7.316e-07, 3.89058561161e-11, 7.318e-07, 3.87848632482e-11, 7.32e-07, 3.86647658879e-11, 7.322e-07, 3.85456191276e-11, 7.324e-07, 3.8427478806e-11, 7.326e-07, 3.83104014266e-11, 7.328e-07, 3.81944440789e-11, 7.33e-07, 3.80796643616e-11, 7.332e-07, 3.79661203083e-11, 7.334e-07, 3.78538703163e-11, 7.336e-07, 3.77429730782e-11, 7.338e-07, 3.76334875164e-11, 7.34e-07, 3.75254727207e-11, 7.342e-07, 3.74189878894e-11, 7.344e-07, 3.7314092273e-11, 7.346e-07, 3.72108451224e-11, 7.348e-07, 3.71093056392e-11, 7.35e-07, 3.70095329303e-11, 7.352e-07, 3.69115859657e-11, 7.354e-07, 3.68155235399e-11, 7.356e-07, 3.67214042364e-11, 7.358e-07, 3.66292863958e-11, 7.36e-07, 3.65392280879e-11, 7.362e-07, 3.64512870861e-11, 7.364e-07, 3.6365520846e-11, 7.366e-07, 3.62819864872e-11, 7.368e-07, 3.62007407776e-11, 7.37e-07, 3.61218401219e-11, 7.372e-07, 3.60453405524e-11, 7.374e-07, 3.5971297723e-11))*V(ns,n)'
Rleak p n 1.0e12
.ends load_model
Xload electrode 0 load_model

.save v(electrode) i(Vsrc)
.control
tran 2e-10 7.3746e-07
wrdata waveform.csv time v(electrode) i(Vsrc)
quit
.endc
.end
