* Auto-generated simulation netlist for case: ccp_gec_level3_topology_and_load_choice
.param C1=6.89530289591e-11
.param C2=8.95172626731e-11
.param Ce=1.17890799912e-10
.param Ch=6.75418319576e-10
.param Csh=3.03533173968e-11
.param L1=3.23067840399e-07
.param Lh=1.28734091663e-06
.param Lp=2.93196940063e-07
.param Rp=88.5139882108
.param Vsrc_amp=576.737862255
.param ne=2.57939576759e+14
.param nu_m=188449103.986

* Sources
Vsrc src 0 SIN(0 576.737862255 13560000 0 0 0)

* Circuit
C1 src 0 {C1}
L1 src electrode {L1}
C2 electrode 0 {C2}
Lh electrode harmonic_mid {Lh}
Ch harmonic_mid 0 {Ch}

* Optional load
* load model: plasma_fixed_rlc
.subckt load_model p n
Rbulk p nb 88.5139882108
Lbulk nb ns 2.93196940063e-07
Csh ns n 3.03533173968e-11
Rleak p n 1e+12
.ends load_model
Xload electrode 0 load_model

.save v(electrode) i(Vsrc)
.control
tran 2e-10 7.3746e-07
wrdata waveform.csv time v(electrode) i(Vsrc)
quit
.endc
.end
